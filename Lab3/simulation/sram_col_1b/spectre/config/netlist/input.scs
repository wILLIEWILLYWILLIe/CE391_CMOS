// Generated for: spectre
// Generated on: Mar 18 10:35:50 2026
// Design library name: my_sram
// Design cell name: Sim_whole_col
// Design view name: config
simulator lang=spectre
global 0
parameters _gpar2 vdd=1.1
include "/vol/eecs391/FreePDK45/ncsu_basekit/models/hspice/hspice_nom.include"

// Library name: EECS391
// Cell name: inverter
// View name: schematic
// Inherited view list: spectre cmos_sch cmos.sch schematic veriloga ahdl
//pspice dspf
subckt inverter gnd in out vdd
    M0 (out in gnd gnd) NMOS_VTG w=400n l=50n as=4.2e-14 ad=4.2e-14 \
        ps=610.0n pd=610.0n ld=105n ls=105n m=1
    M1 (out in vdd vdd) PMOS_VTG w=600n l=50n as=6.3e-14 ad=6.3e-14 \
        ps=810.0n pd=810.0n ld=105n ls=105n m=1
ends inverter
// End of subcircuit definition.

// Library name: my_sram
// Cell name: small_inv
// View name: schematic
// Inherited view list: spectre cmos_sch cmos.sch schematic veriloga ahdl
//pspice dspf
subckt small_inv GND VDD in out
    M0 (out in VDD VDD) PMOS_VTG w=135.00n l=50n as=1.4175e-14 \
        ad=1.4175e-14 ps=345.00n pd=345.00n ld=105n ls=105n m=1
    M1 (out in GND GND) NMOS_VTG w=90n l=50n as=9.45e-15 ad=9.45e-15 \
        ps=300n pd=300n ld=105n ls=105n m=1
ends small_inv
// End of subcircuit definition.

// Library name: my_sram
// Cell name: my4InvLoad
// View name: schematic
// Inherited view list: spectre cmos_sch cmos.sch schematic veriloga ahdl
//pspice dspf
subckt my4InvLoad gnd in out vdd
    I3 (gnd vdd in out) small_inv
    I2 (gnd vdd in out) small_inv
    I1 (gnd vdd in out) small_inv
    I0 (gnd vdd in out) small_inv
ends my4InvLoad
// End of subcircuit definition.

// Library name: my_sram
// Cell name: sram_col_1b
// View name: calibre
// Inherited view list: spectre cmos_sch cmos.sch schematic veriloga ahdl
//pspice dspf
subckt sram_col_1b BL BLB D PRE_B SE WL0 WL1 WL2 WL3 W_EN gnd vdd
    I0_MM3 (I0_MM3_d I0_MM3_g I0_MM3_s I0_MM3_b) NMOS_VTG w=1.35e-07 \
        l=5e-08 as=1.4175e-14 ad=1.4175e-14 ps=4.8e-07 pd=4.8e-07 ld=105n \
        ls=105n m=1
    I0_MM2 (I0_MM2_d I0_MM2_g I0_MM2_s I0_MM2_b) NMOS_VTG w=1.35e-07 \
        l=5e-08 as=1.4175e-14 ad=1.4175e-14 ps=4.8e-07 pd=4.8e-07 ld=105n \
        ls=105n m=1
    I0_MM5 (I0_MM5_d I0_MM5_g I0_MM5_s I0_MM5_b) NMOS_VTG w=2.1e-07 \
        l=5e-08 as=2.94e-14 ad=2.205e-14 ps=7e-07 pd=6.3e-07 ld=105n \
        ls=105n m=1
    I0_MM4 (I0_MM4_d I0_MM4_g I0_MM4_s I0_MM4_b) NMOS_VTG w=2.1e-07 \
        l=5e-08 as=2.94e-14 ad=2.205e-14 ps=7e-07 pd=6.3e-07 ld=105n \
        ls=105n m=1
    I1_MM3 (I1_MM3_d I1_MM3_g I1_MM3_s I1_MM3_b) NMOS_VTG w=1.35e-07 \
        l=5e-08 as=1.4175e-14 ad=1.4175e-14 ps=4.8e-07 pd=4.8e-07 ld=105n \
        ls=105n m=1
    I1_MM2 (I1_MM2_d I1_MM2_g I1_MM2_s I1_MM2_b) NMOS_VTG w=1.35e-07 \
        l=5e-08 as=1.4175e-14 ad=1.4175e-14 ps=4.8e-07 pd=4.8e-07 ld=105n \
        ls=105n m=1
    I1_MM5 (I1_MM5_d I1_MM5_g I1_MM5_s I1_MM5_b) NMOS_VTG w=2.1e-07 \
        l=5e-08 as=2.94e-14 ad=2.205e-14 ps=7e-07 pd=6.3e-07 ld=105n \
        ls=105n m=1
    I1_MM4 (I1_MM4_d I1_MM4_g I1_MM4_s I1_MM4_b) NMOS_VTG w=2.1e-07 \
        l=5e-08 as=2.94e-14 ad=2.205e-14 ps=7e-07 pd=6.3e-07 ld=105n \
        ls=105n m=1
    I2_MM3 (I2_MM3_d I2_MM3_g I2_MM3_s I2_MM3_b) NMOS_VTG w=1.35e-07 \
        l=5e-08 as=1.4175e-14 ad=1.4175e-14 ps=4.8e-07 pd=4.8e-07 ld=105n \
        ls=105n m=1
    I2_MM2 (I2_MM2_d I2_MM2_g I2_MM2_s I2_MM2_b) NMOS_VTG w=1.35e-07 \
        l=5e-08 as=1.4175e-14 ad=1.4175e-14 ps=4.8e-07 pd=4.8e-07 ld=105n \
        ls=105n m=1
    I2_MM5 (I2_MM5_d I2_MM5_g I2_MM5_s I2_MM5_b) NMOS_VTG w=2.1e-07 \
        l=5e-08 as=2.94e-14 ad=2.205e-14 ps=7e-07 pd=6.3e-07 ld=105n \
        ls=105n m=1
    I2_MM4 (I2_MM4_d I2_MM4_g I2_MM4_s I2_MM4_b) NMOS_VTG w=2.1e-07 \
        l=5e-08 as=2.94e-14 ad=2.205e-14 ps=7e-07 pd=6.3e-07 ld=105n \
        ls=105n m=1
    I3_MM3 (I3_MM3_d I3_MM3_g I3_MM3_s I3_MM3_b) NMOS_VTG w=1.35e-07 \
        l=5e-08 as=1.4175e-14 ad=1.4175e-14 ps=4.8e-07 pd=4.8e-07 ld=105n \
        ls=105n m=1
    I3_MM2 (I3_MM2_d I3_MM2_g I3_MM2_s I3_MM2_b) NMOS_VTG w=1.35e-07 \
        l=5e-08 as=1.4175e-14 ad=1.4175e-14 ps=4.8e-07 pd=4.8e-07 ld=105n \
        ls=105n m=1
    I3_MM5 (I3_MM5_d I3_MM5_g I3_MM5_s I3_MM5_b) NMOS_VTG w=2.1e-07 \
        l=5e-08 as=2.94e-14 ad=2.205e-14 ps=7e-07 pd=6.3e-07 ld=105n \
        ls=105n m=1
    I3_MM4 (I3_MM4_d I3_MM4_g I3_MM4_s I3_MM4_b) NMOS_VTG w=2.1e-07 \
        l=5e-08 as=2.94e-14 ad=2.205e-14 ps=7e-07 pd=6.3e-07 ld=105n \
        ls=105n m=1
    I6_MM3 (I6_MM3_d I6_MM3_g I6_MM3_s I6_MM3_b) NMOS_VTG w=9e-08 l=5e-08 \
        as=1.26e-14 ad=9.45e-15 ps=4.6e-07 pd=3.9e-07 ld=105n ls=105n m=1
    I6_MM7 (I6_MM7_d I6_MM7_g I6_MM7_s I6_MM7_b) NMOS_VTG w=9e-08 l=5e-08 \
        as=1.26e-14 ad=9.45e-15 ps=4.6e-07 pd=3.9e-07 ld=105n ls=105n m=1
    I5_I0_MM1 (I5_I0_MM1_d I5_I0_MM1_g I5_I0_MM1_s I5_I0_MM1_b) NMOS_VTG \
        w=9e-08 l=5e-08 as=9.45e-15 ad=9.45e-15 ps=3.9e-07 pd=3.9e-07 \
        ld=105n ls=105n m=1
    I5_MM2 (I5_MM2_d I5_MM2_g I5_net22 I5_MM2_b) NMOS_VTG w=1.8e-07 \
        l=5e-08 as=2.52e-14 ad=1.89e-14 ps=6.4e-07 pd=5.7e-07 ld=105n \
        ls=105n m=1
    I5_MM1 (I5_net20 I5_MM1_g I5_MM1_s I5_MM1_b) NMOS_VTG w=1.8e-07 \
        l=5e-08 as=2.52e-14 ad=2.52e-14 ps=6.4e-07 pd=6.4e-07 ld=105n \
        ls=105n m=1
    I6_MM5 (I6_MM5_d I6_MM5_g I6_MM5_s I6_MM5_b) NMOS_VTG w=9e-08 l=5e-08 \
        as=1.26e-14 ad=9.45e-15 ps=4.6e-07 pd=3.9e-07 ld=105n ls=105n m=1
    I5_MM3 (I5_net22 I5_MM3_g I5_MM3_s I5_MM3_b) NMOS_VTG w=1.8e-07 \
        l=5e-08 as=2.52e-14 ad=2.52e-14 ps=6.4e-07 pd=6.4e-07 ld=105n \
        ls=105n m=1
    I6_MM4 (I6_MM4_d I6_MM4_g I6_MM4_s I6_MM4_b) NMOS_VTG w=9e-08 l=5e-08 \
        as=1.26e-14 ad=9.45e-15 ps=4.6e-07 pd=3.9e-07 ld=105n ls=105n m=1
    I5_MM0 (I5_MM0_d I5_MM0_g I5_net20 I5_MM0_b) NMOS_VTG w=1.8e-07 \
        l=5e-08 as=2.52e-14 ad=1.89e-14 ps=6.4e-07 pd=5.7e-07 ld=105n \
        ls=105n m=1
    I0_MM7 (I0_MM7_d I0_MM7_g I0_MM7_s I0_MM7_b) PMOS_VTG w=9e-08 l=5e-08 \
        as=1.26e-14 ad=9.45e-15 ps=4.6e-07 pd=3.9e-07 ld=105n ls=105n m=1
    I0_MM6 (I0_MM6_d I0_MM6_g I0_MM6_s I0_MM6_b) PMOS_VTG w=9e-08 l=5e-08 \
        as=1.26e-14 ad=9.45e-15 ps=4.6e-07 pd=3.9e-07 ld=105n ls=105n m=1
    I1_MM7 (I1_MM7_d I1_MM7_g I1_MM7_s I1_MM7_b) PMOS_VTG w=9e-08 l=5e-08 \
        as=1.26e-14 ad=9.45e-15 ps=4.6e-07 pd=3.9e-07 ld=105n ls=105n m=1
    I1_MM6 (I1_MM6_d I1_MM6_g I1_MM6_s I1_MM6_b) PMOS_VTG w=9e-08 l=5e-08 \
        as=1.26e-14 ad=9.45e-15 ps=4.6e-07 pd=3.9e-07 ld=105n ls=105n m=1
    I2_MM7 (I2_MM7_d I2_MM7_g I2_MM7_s I2_MM7_b) PMOS_VTG w=9e-08 l=5e-08 \
        as=1.26e-14 ad=9.45e-15 ps=4.6e-07 pd=3.9e-07 ld=105n ls=105n m=1
    I2_MM6 (I2_MM6_d I2_MM6_g I2_MM6_s I2_MM6_b) PMOS_VTG w=9e-08 l=5e-08 \
        as=1.26e-14 ad=9.45e-15 ps=4.6e-07 pd=3.9e-07 ld=105n ls=105n m=1
    I3_MM7 (I3_MM7_d I3_MM7_g I3_MM7_s I3_MM7_b) PMOS_VTG w=9e-08 l=5e-08 \
        as=1.26e-14 ad=9.45e-15 ps=4.6e-07 pd=3.9e-07 ld=105n ls=105n m=1
    I3_MM6 (I3_MM6_d I3_MM6_g I3_MM6_s I3_MM6_b) PMOS_VTG w=9e-08 l=5e-08 \
        as=1.26e-14 ad=9.45e-15 ps=4.6e-07 pd=3.9e-07 ld=105n ls=105n m=1
    I6_MM0 (I6_MM0_d I6_MM0_g I6_MM0_s I6_MM0_b) PMOS_VTG w=1.35e-07 \
        l=5e-08 as=1.89e-14 ad=1.4175e-14 ps=5.5e-07 pd=4.8e-07 ld=105n \
        ls=105n m=1
    I6_MM6 (I6_MM6_d I6_MM6_g I6_MM6_s I6_MM6_b) PMOS_VTG w=1.35e-07 \
        l=5e-08 as=1.89e-14 ad=1.4175e-14 ps=5.5e-07 pd=4.8e-07 ld=105n \
        ls=105n m=1
    I5_I0_MM0 (I5_I0_MM0_d I5_I0_MM0_g I5_I0_MM0_s I5_I0_MM0_b) PMOS_VTG \
        w=1.35e-07 l=5e-08 as=1.4175e-14 ad=1.4175e-14 ps=4.8e-07 \
        pd=4.8e-07 ld=105n ls=105n m=1
    I6_MM2 (I6_MM2_d I6_MM2_g I6_MM2_s I6_MM2_b) PMOS_VTG w=1.35e-07 \
        l=5e-08 as=1.89e-14 ad=1.4175e-14 ps=5.5e-07 pd=4.8e-07 ld=105n \
        ls=105n m=1
    I4_MM2 (I4_MM2_d I4_MM2_g I4_MM2_s I4_MM2_b) PMOS_VTG w=9e-08 l=5e-08 \
        as=9.45e-15 ad=1.26e-14 ps=3.9e-07 pd=4.6e-07 ld=105n ls=105n m=1
    I4_MM1 (I4_MM1_d I4_MM1_g I4_MM1_s I4_MM1_b) PMOS_VTG w=1.8e-07 \
        l=5e-08 as=2.52e-14 ad=1.89e-14 ps=6.4e-07 pd=5.7e-07 ld=105n \
        ls=105n m=1
    I6_MM1 (I6_MM1_d I6_MM1_g I6_MM1_s I6_MM1_b) PMOS_VTG w=1.35e-07 \
        l=5e-08 as=1.89e-14 ad=1.4175e-14 ps=5.5e-07 pd=4.8e-07 ld=105n \
        ls=105n m=1
    I4_MM2\@2 (I4_MM2\@2_d I4_MM2\@2_g I4_MM2\@2_s I4_MM2\@2_b) PMOS_VTG \
        w=9e-08 l=5e-08 as=9.45e-15 ad=1.26e-14 ps=3.9e-07 pd=4.6e-07 \
        ld=105n ls=105n m=1
    I4_MM0 (I4_MM0_d I4_MM0_g I4_MM0_s I4_MM0_b) PMOS_VTG w=1.8e-07 \
        l=5e-08 as=2.52e-14 ad=1.89e-14 ps=6.4e-07 pd=5.7e-07 ld=105n \
        ls=105n m=1
    cc_899 (I1_MM3_s c_1773_n) capacitor c=2.24665e-18
    cc_898 (I1_MM4_g c_1773_n) capacitor c=1.32425e-18
    cc_897 (I1_MM4_d c_1773_n) capacitor c=4.77001e-19
    cc_896 (c_226_n c_1773_n) capacitor c=6.62471e-19
    cc_895 (I1_MM2_s c_1773_n) capacitor c=2.24218e-18
    cc_894 (I1_MM5_g c_1773_n) capacitor c=1.32425e-18
    cc_893 (I2_MM3_s c_1747_n) capacitor c=2.24665e-18
    cc_892 (I2_MM4_g c_1747_n) capacitor c=1.32425e-18
    cc_891 (I2_MM4_d c_1747_n) capacitor c=4.77001e-19
    cc_890 (c_115_n c_1747_n) capacitor c=6.62471e-19
    cc_889 (I2_MM2_s c_1747_n) capacitor c=2.24218e-18
    cc_888 (I2_MM5_g c_1747_n) capacitor c=1.32425e-18
    cc_887 (I3_MM3_s c_1721_n) capacitor c=2.24665e-18
    cc_886 (I3_MM4_g c_1721_n) capacitor c=1.32425e-18
    cc_885 (I3_MM4_d c_1721_n) capacitor c=4.77001e-19
    cc_884 (c_8_n c_1721_n) capacitor c=6.62471e-19
    cc_883 (I3_MM2_s c_1721_n) capacitor c=2.24218e-18
    cc_882 (I3_MM5_g c_1721_n) capacitor c=1.32425e-18
    cc_881 (I0_MM3_s c_1694_n) capacitor c=2.24665e-18
    cc_880 (I0_MM4_g c_1694_n) capacitor c=1.32425e-18
    cc_879 (I0_MM4_d c_1694_n) capacitor c=4.77001e-19
    cc_878 (c_336_n c_1694_n) capacitor c=6.62471e-19
    cc_877 (I0_MM2_s c_1694_n) capacitor c=2.24218e-18
    cc_876 (I0_MM5_g c_1694_n) capacitor c=1.32425e-18
    cc_875 (I0_MM6_g c_1665_n) capacitor c=1.11317e-18
    cc_874 (I0_MM7_g c_1674_n) capacitor c=1.11317e-18
    cc_873 (c_387_n c_1465_n) capacitor c=2.1029e-18
    cc_872 (c_392_n c_1465_n) capacitor c=2.08338e-18
    cc_871 (I0_MM6_g c_1465_n) capacitor c=4.42067e-19
    cc_870 (I0_MM7_d c_1503_n) capacitor c=1.71591e-16
    cc_869 (c_392_n c_1503_n) capacitor c=6.74673e-19
    cc_868 (I0_MM7_d I0_MM6_s) capacitor c=2.21956e-17
    cc_867 (c_392_n I0_MM6_s) capacitor c=1.30391e-17
    cc_866 (I0_MM6_g I0_MM6_s) capacitor c=1.03048e-18
    cc_865 (I0_MM7_g c_1465_n) capacitor c=4.42067e-19
    cc_864 (c_331_n I0_MM6_s) capacitor c=2.66111e-17
    cc_863 (I0_MM7_g I0_MM6_s) capacitor c=1.0188e-18
    cc_862 (c_277_n c_1464_n) capacitor c=2.34386e-18
    cc_861 (c_281_n c_1464_n) capacitor c=2.25656e-18
    cc_860 (I1_MM6_g c_1464_n) capacitor c=4.61626e-19
    cc_859 (I1_MM7_d c_1501_n) capacitor c=1.97836e-16
    cc_858 (c_281_n c_1501_n) capacitor c=6.75811e-19
    cc_857 (I1_MM7_d I1_MM6_s) capacitor c=2.21956e-17
    cc_856 (c_281_n I1_MM6_s) capacitor c=1.30694e-17
    cc_855 (I1_MM6_g I1_MM6_s) capacitor c=1.03048e-18
    cc_854 (I1_MM7_g c_1464_n) capacitor c=4.61626e-19
    cc_853 (c_230_n I1_MM6_s) capacitor c=2.66111e-17
    cc_852 (I1_MM7_g I1_MM6_s) capacitor c=1.0188e-18
    cc_851 (c_166_n c_1464_n) capacitor c=2.34386e-18
    cc_850 (c_170_n c_1464_n) capacitor c=2.25656e-18
    cc_849 (I2_MM6_g c_1464_n) capacitor c=4.61626e-19
    cc_848 (I2_MM7_d c_1501_n) capacitor c=1.29649e-16
    cc_847 (c_170_n c_1501_n) capacitor c=6.51523e-19
    cc_846 (I2_MM7_d I2_MM6_s) capacitor c=2.21956e-17
    cc_845 (c_170_n I2_MM6_s) capacitor c=1.30694e-17
    cc_844 (I2_MM6_g I2_MM6_s) capacitor c=1.03048e-18
    cc_843 (I2_MM7_g c_1464_n) capacitor c=4.61626e-19
    cc_842 (c_119_n I2_MM6_s) capacitor c=2.66111e-17
    cc_841 (I2_MM7_g I2_MM6_s) capacitor c=1.0188e-18
    cc_840 (c_57_n c_1467_n) capacitor c=2.96931e-18
    cc_839 (c_61_n c_1467_n) capacitor c=2.32176e-18
    cc_838 (I3_MM6_g c_1467_n) capacitor c=1.39491e-18
    cc_837 (I3_MM7_d c_1508_n) capacitor c=1.71444e-16
    cc_836 (c_61_n c_1508_n) capacitor c=6.14656e-19
    cc_835 (I3_MM7_d I3_MM6_s) capacitor c=2.21956e-17
    cc_834 (c_61_n I3_MM6_s) capacitor c=1.22995e-17
    cc_833 (I3_MM6_g I3_MM6_s) capacitor c=1.03048e-18
    cc_832 (I3_MM7_g c_1467_n) capacitor c=1.34038e-18
    cc_831 (c_2_n I3_MM6_s) capacitor c=2.66111e-17
    cc_830 (I3_MM7_g I3_MM6_s) capacitor c=1.0188e-18
    cc_829 (WL1 c_1501_n) capacitor c=3.25546e-19
    cc_828 (c_1754_n c_1501_n) capacitor c=3.21912e-19
    cc_827 (c_1728_n c_1508_n) capacitor c=3.26876e-19
    cc_826 (c_1701_n c_1528_n) capacitor c=7.06981e-19
    cc_825 (c_1701_n c_1503_n) capacitor c=3.27693e-19
    cc_824 (c_1682_n c_1503_n) capacitor c=8.39083e-19
    cc_823 (c_1690_n c_1503_n) capacitor c=2.77865e-19
    cc_822 (PRE_B c_1503_n) capacitor c=1.60657e-18
    cc_821 (c_1674_n c_1465_n) capacitor c=4.52243e-19
    cc_820 (c_1674_n I4_MM0_s) capacitor c=1.03048e-18
    cc_819 (c_1665_n c_1465_n) capacitor c=4.52243e-19
    cc_818 (c_1665_n I4_MM0_s) capacitor c=1.01363e-18
    cc_817 (c_1609_n c_1468_n) capacitor c=1.12149e-18
    cc_816 (c_1609_n I6_MM6_s) capacitor c=1.25243e-17
    cc_815 (c_1607_n I6_MM6_s) capacitor c=1.77619e-17
    cc_814 (c_1600_n c_1462_n) capacitor c=3.50942e-19
    cc_813 (I6_MM2_g c_1468_n) capacitor c=5.11835e-19
    cc_812 (I6_MM2_g I6_MM6_s) capacitor c=9.23e-19
    cc_811 (c_397_n I0_MM4_s) capacitor c=3.65038e-17
    cc_810 (I0_MM3_s I0_MM4_s) capacitor c=6.98692e-18
    cc_809 (I0_MM4_g I0_MM4_s) capacitor c=6.73807e-19
    cc_808 (c_336_n c_1246_n) capacitor c=6.6187e-19
    cc_807 (c_336_n c_1315_n) capacitor c=8.11916e-19
    cc_806 (c_336_n I0_MM4_s) capacitor c=1.80344e-17
    cc_805 (c_335_n I0_MM4_s) capacitor c=4.30409e-17
    cc_804 (I0_MM2_s I0_MM4_s) capacitor c=7.56497e-18
    cc_803 (I0_MM5_g I0_MM4_s) capacitor c=6.70245e-19
    cc_802 (I1_MM7_d c_1326_n) capacitor c=8.59426e-18
    cc_801 (c_286_n c_1326_n) capacitor c=7.71202e-19
    cc_800 (I1_MM3_s c_1326_n) capacitor c=8.16885e-19
    cc_799 (I1_MM3_s I1_MM4_s) capacitor c=6.98692e-18
    cc_798 (I1_MM5_d I1_MM4_s) capacitor c=3.65038e-17
    cc_797 (I1_MM4_g I1_MM4_s) capacitor c=6.73807e-19
    cc_796 (c_226_n c_1246_n) capacitor c=6.6187e-19
    cc_795 (c_226_n c_1315_n) capacitor c=8.11916e-19
    cc_794 (I1_MM4_d I1_MM4_s) capacitor c=4.30409e-17
    cc_793 (c_226_n I1_MM4_s) capacitor c=1.80344e-17
    cc_792 (I1_MM2_s I1_MM4_s) capacitor c=7.56497e-18
    cc_791 (I1_MM5_g I1_MM4_s) capacitor c=6.70245e-19
    cc_790 (I2_MM7_d c_1326_n) capacitor c=2.51383e-19
    cc_789 (c_175_n c_1326_n) capacitor c=7.71202e-19
    cc_788 (I2_MM3_s c_1326_n) capacitor c=8.16885e-19
    cc_787 (I2_MM5_d c_1326_n) capacitor c=8.34287e-18
    cc_786 (c_175_n I2_MM4_s) capacitor c=3.65038e-17
    cc_785 (I2_MM3_s I2_MM4_s) capacitor c=6.98692e-18
    cc_784 (I2_MM4_g I2_MM4_s) capacitor c=6.73807e-19
    cc_783 (c_115_n c_1241_n) capacitor c=6.6187e-19
    cc_782 (c_115_n c_1312_n) capacitor c=8.11916e-19
    cc_781 (c_115_n I2_MM4_s) capacitor c=1.80344e-17
    cc_780 (c_114_n I2_MM4_s) capacitor c=4.30409e-17
    cc_779 (I2_MM2_s I2_MM4_s) capacitor c=7.56497e-18
    cc_778 (I2_MM5_g I2_MM4_s) capacitor c=6.70245e-19
    cc_777 (I3_MM7_d c_1326_n) capacitor c=8.59426e-18
    cc_776 (c_66_n c_1326_n) capacitor c=7.71202e-19
    cc_775 (I3_MM3_s c_1326_n) capacitor c=8.16885e-19
    cc_774 (I3_MM3_s I3_MM4_s) capacitor c=6.98692e-18
    cc_773 (I3_MM5_d I3_MM4_s) capacitor c=3.65038e-17
    cc_772 (I3_MM4_g I3_MM4_s) capacitor c=6.73807e-19
    cc_771 (c_8_n c_1241_n) capacitor c=6.6187e-19
    cc_770 (c_8_n c_1312_n) capacitor c=8.11916e-19
    cc_769 (I3_MM4_d I3_MM4_s) capacitor c=4.30409e-17
    cc_768 (c_8_n I3_MM4_s) capacitor c=1.80344e-17
    cc_767 (I3_MM2_s I3_MM4_s) capacitor c=7.56497e-18
    cc_766 (I3_MM5_g I3_MM4_s) capacitor c=6.70245e-19
    cc_765 (WL1 c_1343_n) capacitor c=5.52201e-18
    cc_764 (WL1 c_1326_n) capacitor c=1.89837e-18
    cc_763 (WL1 I1_MM4_s) capacitor c=1.67842e-18
    cc_762 (c_1773_n c_1343_n) capacitor c=1.08924e-18
    cc_761 (c_1773_n c_1246_n) capacitor c=1.33861e-18
    cc_760 (c_1773_n c_1315_n) capacitor c=1.42086e-18
    cc_759 (c_1773_n I1_MM4_s) capacitor c=6.83142e-18
    cc_758 (c_1776_n c_1343_n) capacitor c=4.0166e-19
    cc_757 (c_1776_n I1_MM4_s) capacitor c=2.16098e-19
    cc_756 (c_1754_n c_1341_n) capacitor c=4.3087e-18
    cc_755 (c_1754_n c_1326_n) capacitor c=1.89837e-18
    cc_754 (c_1754_n I2_MM4_s) capacitor c=1.67842e-18
    cc_753 (c_1747_n c_1341_n) capacitor c=9.99093e-19
    cc_752 (c_1747_n c_1241_n) capacitor c=1.33861e-18
    cc_751 (c_1747_n c_1312_n) capacitor c=1.42086e-18
    cc_750 (c_1747_n I2_MM4_s) capacitor c=6.83142e-18
    cc_749 (c_1750_n c_1341_n) capacitor c=3.69327e-19
    cc_748 (c_1750_n I2_MM4_s) capacitor c=2.16098e-19
    cc_747 (c_1728_n c_1341_n) capacitor c=4.92903e-18
    cc_746 (c_1728_n c_1326_n) capacitor c=1.89837e-18
    cc_745 (c_1728_n I3_MM4_s) capacitor c=1.67842e-18
    cc_744 (c_1721_n c_1341_n) capacitor c=1.03881e-18
    cc_743 (c_1721_n c_1241_n) capacitor c=1.33861e-18
    cc_742 (c_1721_n c_1312_n) capacitor c=1.42086e-18
    cc_741 (c_1721_n I3_MM4_s) capacitor c=6.83142e-18
    cc_740 (c_1724_n c_1341_n) capacitor c=3.83313e-19
    cc_739 (c_1724_n I3_MM4_s) capacitor c=2.16098e-19
    cc_738 (c_1701_n c_1343_n) capacitor c=5.52201e-18
    cc_737 (c_1701_n c_1326_n) capacitor c=8.17691e-19
    cc_736 (c_1701_n I0_MM4_s) capacitor c=1.67842e-18
    cc_735 (c_1694_n c_1343_n) capacitor c=1.08973e-18
    cc_734 (c_1694_n c_1246_n) capacitor c=1.33861e-18
    cc_733 (c_1694_n c_1315_n) capacitor c=1.42086e-18
    cc_732 (c_1694_n I0_MM4_s) capacitor c=6.83142e-18
    cc_731 (c_1697_n c_1343_n) capacitor c=4.01757e-19
    cc_730 (c_1697_n I0_MM4_s) capacitor c=2.16098e-19
    cc_729 (c_1616_n c_1238_n) capacitor c=3.68638e-19
    cc_728 (c_1609_n c_1254_n) capacitor c=3.52246e-19
    cc_727 (c_1609_n c_1252_n) capacitor c=3.21494e-19
    cc_726 (c_1609_n I5_MM1_s) capacitor c=9.60679e-19
    cc_725 (c_1603_n c_1238_n) capacitor c=2.71594e-19
    cc_724 (I6_MM7_d I6_MM7_s) capacitor c=9.01351e-18
    cc_723 (c_1468_n c_1254_n) capacitor c=3.36649e-18
    cc_722 (c_1468_n c_1335_n) capacitor c=7.74157e-18
    cc_721 (c_1468_n c_1326_n) capacitor c=1.24503e-17
    cc_720 (c_1533_n c_1254_n) capacitor c=8.70179e-19
    cc_719 (c_1528_n c_1254_n) capacitor c=9.68538e-18
    cc_718 (c_1528_n c_1335_n) capacitor c=5.53915e-19
    cc_717 (c_1528_n c_1347_p) capacitor c=1.28814e-17
    cc_716 (c_1528_n c_1346_p) capacitor c=5.64686e-18
    cc_715 (c_1528_n c_1357_p) capacitor c=5.98352e-19
    cc_714 (c_1467_n c_1238_n) capacitor c=9.15244e-19
    cc_713 (c_1508_n c_1341_n) capacitor c=1.41464e-18
    cc_712 (c_1508_n c_1254_n) capacitor c=5.5419e-18
    cc_711 (c_1508_n c_1346_p) capacitor c=1.09746e-18
    cc_710 (c_1508_n c_1326_n) capacitor c=1.18794e-17
    cc_709 (c_1508_n c_1285_n) capacitor c=2.33347e-19
    cc_708 (c_1503_n c_1343_n) capacitor c=2.75277e-18
    cc_707 (c_1501_n c_1343_n) capacitor c=1.45945e-18
    cc_706 (c_1501_n c_1341_n) capacitor c=1.37226e-18
    cc_705 (c_1501_n c_1347_p) capacitor c=1.31521e-18
    cc_704 (c_1501_n c_1346_p) capacitor c=1.06458e-18
    cc_703 (c_1501_n c_1326_n) capacitor c=1.13898e-17
    cc_702 (I0_MM3_s c_1000_n) capacitor c=9.59622e-19
    cc_701 (c_399_n c_1054_p) capacitor c=3.95866e-18
    cc_700 (I0_MM7_d c_1054_p) capacitor c=7.55028e-18
    cc_699 (c_397_n c_1054_p) capacitor c=3.51523e-18
    cc_698 (c_387_n c_1054_p) capacitor c=7.56917e-19
    cc_697 (c_386_n c_1054_p) capacitor c=2.98217e-18
    cc_696 (c_385_n c_1054_p) capacitor c=1.52797e-17
    cc_695 (I0_MM3_s c_1054_p) capacitor c=4.91808e-18
    cc_694 (c_392_n c_1054_p) capacitor c=2.83848e-18
    cc_693 (I0_MM5_d c_1054_p) capacitor c=7.17384e-18
    cc_692 (c_387_n c_974_n) capacitor c=2.30244e-19
    cc_691 (I0_MM3_s I0_MM3_d) capacitor c=4.10689e-17
    cc_690 (c_336_n c_1054_p) capacitor c=3.51082e-18
    cc_689 (c_333_n c_1054_p) capacitor c=7.83577e-19
    cc_688 (c_332_n c_1054_p) capacitor c=5.44303e-19
    cc_687 (I0_MM5_g c_1054_p) capacitor c=9.74992e-18
    cc_686 (I1_MM3_s c_999_n) capacitor c=9.59622e-19
    cc_685 (c_288_n c_1046_p) capacitor c=3.95866e-18
    cc_684 (I1_MM7_d c_1046_p) capacitor c=7.53127e-18
    cc_683 (c_286_n c_1046_p) capacitor c=3.51523e-18
    cc_682 (c_277_n c_1046_p) capacitor c=7.56917e-19
    cc_681 (c_276_n c_1046_p) capacitor c=2.98217e-18
    cc_680 (c_275_n c_1046_p) capacitor c=1.52797e-17
    cc_679 (I1_MM3_s c_1046_p) capacitor c=4.9659e-18
    cc_678 (c_281_n c_1046_p) capacitor c=2.83824e-18
    cc_677 (I1_MM5_d c_1046_p) capacitor c=7.17384e-18
    cc_676 (I1_MM3_s I1_MM3_d) capacitor c=4.10689e-17
    cc_675 (c_227_n c_1046_p) capacitor c=3.51082e-18
    cc_674 (c_223_n c_1046_p) capacitor c=7.83577e-19
    cc_673 (c_222_n c_1046_p) capacitor c=5.44303e-19
    cc_672 (I1_MM7_g c_1046_p) capacitor c=9.74992e-18
    cc_671 (I2_MM3_s c_998_n) capacitor c=9.59622e-19
    cc_670 (c_177_n c_1046_p) capacitor c=3.95866e-18
    cc_669 (I2_MM7_d c_1046_p) capacitor c=7.58754e-18
    cc_668 (c_175_n c_1046_p) capacitor c=3.51523e-18
    cc_667 (c_166_n c_1046_p) capacitor c=7.56917e-19
    cc_666 (c_165_n c_1046_p) capacitor c=2.98217e-18
    cc_665 (c_164_n c_1046_p) capacitor c=1.52797e-17
    cc_664 (I2_MM3_s c_1046_p) capacitor c=4.9659e-18
    cc_663 (c_170_n c_1046_p) capacitor c=2.83894e-18
    cc_662 (I2_MM5_d c_1046_p) capacitor c=7.17384e-18
    cc_661 (I2_MM3_s I2_MM3_d) capacitor c=4.10689e-17
    cc_660 (c_115_n c_1046_p) capacitor c=3.51082e-18
    cc_659 (c_112_n c_1046_p) capacitor c=7.83577e-19
    cc_658 (c_111_n c_1046_p) capacitor c=5.44303e-19
    cc_657 (I2_MM5_g c_1046_p) capacitor c=9.74992e-18
    cc_656 (I3_MM3_s c_997_n) capacitor c=9.59622e-19
    cc_655 (c_68_n c_1012_n) capacitor c=3.25505e-18
    cc_654 (I3_MM7_d c_1012_n) capacitor c=7.55028e-18
    cc_653 (c_66_n c_1012_n) capacitor c=3.51523e-18
    cc_652 (c_57_n c_1012_n) capacitor c=7.56917e-19
    cc_651 (c_56_n c_1012_n) capacitor c=2.98217e-18
    cc_650 (c_55_n c_1012_n) capacitor c=1.52797e-17
    cc_649 (I3_MM3_s c_1012_n) capacitor c=4.91808e-18
    cc_648 (c_61_n c_1012_n) capacitor c=2.63281e-18
    cc_647 (I3_MM5_d c_1012_n) capacitor c=6.97347e-18
    cc_646 (I3_MM3_s I3_MM3_d) capacitor c=4.10689e-17
    cc_645 (c_9_n c_1012_n) capacitor c=3.51082e-18
    cc_644 (c_5_n c_1012_n) capacitor c=7.83577e-19
    cc_643 (c_4_n c_1012_n) capacitor c=5.44303e-19
    cc_642 (I3_MM7_g c_1012_n) capacitor c=9.74992e-18
    cc_641 (WL1 c_999_n) capacitor c=2.69487e-19
    cc_640 (WL1 c_1046_p) capacitor c=1.7386e-18
    cc_639 (WL1 I1_MM3_d) capacitor c=5.46324e-17
    cc_638 (c_1773_n c_999_n) capacitor c=8.84353e-19
    cc_637 (c_1773_n c_1046_p) capacitor c=3.78947e-18
    cc_636 (c_1773_n I1_MM3_d) capacitor c=2.20485e-18
    cc_635 (c_1776_n c_1046_p) capacitor c=3.29077e-19
    cc_634 (c_1754_n c_998_n) capacitor c=2.69487e-19
    cc_633 (c_1754_n c_1046_p) capacitor c=1.7386e-18
    cc_632 (c_1754_n I2_MM3_d) capacitor c=5.46324e-17
    cc_631 (c_1747_n c_998_n) capacitor c=8.84353e-19
    cc_630 (c_1747_n c_1046_p) capacitor c=3.78947e-18
    cc_629 (c_1747_n I2_MM3_d) capacitor c=2.20485e-18
    cc_628 (c_1750_n c_1046_p) capacitor c=3.29077e-19
    cc_627 (c_1728_n c_997_n) capacitor c=2.69487e-19
    cc_626 (c_1728_n c_1012_n) capacitor c=1.7386e-18
    cc_625 (c_1728_n I3_MM3_d) capacitor c=5.46324e-17
    cc_624 (c_1721_n c_997_n) capacitor c=8.84353e-19
    cc_623 (c_1721_n c_1012_n) capacitor c=3.78947e-18
    cc_622 (c_1721_n I3_MM3_d) capacitor c=2.20485e-18
    cc_621 (c_1724_n c_1012_n) capacitor c=3.29077e-19
    cc_620 (c_1701_n c_1000_n) capacitor c=2.69487e-19
    cc_619 (c_1701_n c_1054_p) capacitor c=1.7386e-18
    cc_618 (c_1701_n I0_MM3_d) capacitor c=5.46324e-17
    cc_617 (c_1694_n c_1000_n) capacitor c=8.84353e-19
    cc_616 (c_1694_n c_1054_p) capacitor c=3.78947e-18
    cc_615 (c_1694_n I0_MM3_d) capacitor c=2.20485e-18
    cc_614 (c_1697_n c_1054_p) capacitor c=3.29077e-19
    cc_613 (c_1682_n c_1127_p) capacitor c=1.63257e-18
    cc_612 (c_1682_n I4_MM2_s) capacitor c=4.44472e-18
    cc_611 (c_1682_n c_974_n) capacitor c=7.40747e-19
    cc_610 (PRE_B c_1127_p) capacitor c=2.28595e-17
    cc_609 (c_1680_n c_974_n) capacitor c=7.5052e-19
    cc_608 (c_1678_n c_974_n) capacitor c=8.59334e-19
    cc_607 (c_1678_n I4_MM2\@2_s) capacitor c=2.02031e-18
    cc_606 (c_1670_n I4_MM2_s) capacitor c=3.04473e-18
    cc_605 (c_1674_n I4_MM1_d) capacitor c=4.35922e-18
    cc_604 (c_1674_n c_1054_p) capacitor c=2.16904e-18
    cc_603 (c_1674_n c_974_n) capacitor c=3.97318e-18
    cc_602 (c_1669_n c_974_n) capacitor c=4.77337e-18
    cc_601 (c_1667_n I4_MM2\@2_s) capacitor c=2.02031e-18
    cc_600 (c_1665_n c_974_n) capacitor c=4.21033e-18
    cc_599 (c_1609_n c_1007_n) capacitor c=2.99799e-18
    cc_598 (c_1608_n c_1007_n) capacitor c=7.77999e-19
    cc_597 (I6_MM2_g c_1007_n) capacitor c=2.03118e-18
    cc_596 (c_1468_n c_1007_n) capacitor c=1.03942e-17
    cc_595 (c_1468_n I5_MM2_d) capacitor c=2.71356e-19
    cc_594 (c_1468_n c_1003_n) capacitor c=1.50778e-17
    cc_593 (c_1468_n c_1001_n) capacitor c=2.23119e-18
    cc_592 (c_1468_n c_980_n) capacitor c=4.61203e-19
    cc_591 (c_1467_n c_1012_n) capacitor c=9.86951e-19
    cc_590 (c_1508_n c_1107_p) capacitor c=5.68664e-18
    cc_589 (c_1508_n c_1012_n) capacitor c=1.00397e-17
    cc_588 (c_1465_n c_1054_p) capacitor c=8.52461e-19
    cc_587 (c_1465_n c_974_n) capacitor c=5.06699e-18
    cc_586 (c_1503_n I4_MM1_d) capacitor c=1.6981e-16
    cc_585 (c_1503_n c_1054_p) capacitor c=9.04412e-18
    cc_584 (c_1503_n c_974_n) capacitor c=9.91537e-19
    cc_583 (c_1464_n c_1046_p) capacitor c=1.19823e-18
    cc_582 (c_1501_n c_1046_p) capacitor c=8.21826e-18
    cc_581 (I6_MM6_s c_1007_n) capacitor c=4.26716e-19
    cc_580 (I4_MM0_s I4_MM1_d) capacitor c=2.55358e-17
    cc_579 (I4_MM0_s c_1054_p) capacitor c=3.28907e-18
    cc_578 (I4_MM0_s c_974_n) capacitor c=1.25428e-17
    cc_577 (I0_MM6_s c_1054_p) capacitor c=3.87327e-18
    cc_576 (I1_MM6_s c_1046_p) capacitor c=3.50592e-18
    cc_575 (I2_MM6_s c_1046_p) capacitor c=3.51442e-18
    cc_574 (I3_MM6_s c_1012_n) capacitor c=3.51442e-18
    cc_573 (I5_I0_MM0_s c_1012_n) capacitor c=1.52214e-18
    cc_572 (c_1343_n I0_MM3_d) capacitor c=5.19631e-17
    cc_571 (c_1343_n I1_MM3_d) capacitor c=5.19631e-17
    cc_570 (c_1341_n I2_MM3_d) capacitor c=1.64969e-17
    cc_569 (c_1341_n I3_MM3_d) capacitor c=3.24563e-17
    cc_568 (c_1254_n I5_MM2_d) capacitor c=6.29643e-17
    cc_567 (c_1254_n c_1005_n) capacitor c=6.07933e-19
    cc_566 (c_1254_n c_1004_n) capacitor c=8.65606e-18
    cc_565 (c_1254_n c_1018_n) capacitor c=2.10592e-18
    cc_564 (c_1335_n c_1001_n) capacitor c=1.17427e-18
    cc_563 (c_1335_n c_1070_p) capacitor c=4.5294e-19
    cc_562 (c_1326_n I5_MM2_d) capacitor c=7.43473e-19
    cc_561 (c_1326_n c_1001_n) capacitor c=4.69785e-17
    cc_560 (c_1326_n c_1070_p) capacitor c=4.32144e-18
    cc_559 (c_1326_n c_988_n) capacitor c=9.77227e-19
    cc_558 (c_1326_n I6_MM3_d) capacitor c=2.23721e-18
    cc_557 (c_1326_n I0_MM3_d) capacitor c=3.87592e-19
    cc_556 (c_1326_n I1_MM3_d) capacitor c=3.87592e-19
    cc_555 (c_1326_n I2_MM3_d) capacitor c=3.87592e-19
    cc_554 (c_1326_n I3_MM3_d) capacitor c=3.87592e-19
    cc_553 (c_1276_n c_1070_p) capacitor c=2.21722e-19
    cc_552 (c_1276_n I6_MM3_d) capacitor c=3.80385e-16
    cc_551 (c_1276_n c_980_n) capacitor c=3.00471e-19
    cc_550 (c_1322_n c_1050_p) capacitor c=6.03058e-18
    cc_549 (c_1321_n c_1042_p) capacitor c=5.84684e-18
    cc_548 (c_1285_n c_1004_n) capacitor c=4.24316e-19
    cc_547 (c_1285_n c_1018_n) capacitor c=2.26511e-19
    cc_546 (c_1275_n c_980_n) capacitor c=1.35059e-18
    cc_545 (c_1315_n c_1050_p) capacitor c=4.82204e-18
    cc_544 (c_1315_n I0_MM3_d) capacitor c=4.96707e-16
    cc_543 (c_1315_n I1_MM3_d) capacitor c=4.96707e-16
    cc_542 (c_1312_n c_1042_p) capacitor c=4.82204e-18
    cc_541 (c_1312_n I2_MM3_d) capacitor c=4.96707e-16
    cc_540 (c_1312_n I3_MM3_d) capacitor c=4.96707e-16
    cc_539 (I5_MM1_s I5_MM2_d) capacitor c=1.03205e-18
    cc_538 (I0_MM4_s c_1000_n) capacitor c=2.2255e-19
    cc_537 (I0_MM4_s c_1054_p) capacitor c=5.49649e-18
    cc_536 (I0_MM4_s c_1050_p) capacitor c=1.65103e-18
    cc_535 (I0_MM4_s I0_MM3_d) capacitor c=4.64266e-17
    cc_534 (I1_MM4_s c_999_n) capacitor c=2.2255e-19
    cc_533 (I1_MM4_s c_1050_p) capacitor c=1.57538e-18
    cc_532 (I1_MM4_s c_1046_p) capacitor c=5.49649e-18
    cc_531 (I1_MM4_s I1_MM3_d) capacitor c=4.64266e-17
    cc_530 (I2_MM4_s c_998_n) capacitor c=2.2255e-19
    cc_529 (I2_MM4_s c_1046_p) capacitor c=5.49649e-18
    cc_528 (I2_MM4_s c_1042_p) capacitor c=1.65103e-18
    cc_527 (I2_MM4_s I2_MM3_d) capacitor c=4.64266e-17
    cc_526 (I3_MM4_s c_997_n) capacitor c=2.2255e-19
    cc_525 (I3_MM4_s c_1042_p) capacitor c=1.54386e-18
    cc_524 (I3_MM4_s c_1012_n) capacitor c=5.49649e-18
    cc_523 (I3_MM4_s I3_MM3_d) capacitor c=4.64266e-17
    cc_522 (c_1609_n c_934_n) capacitor c=1.28917e-18
    cc_521 (c_1609_n c_944_p) capacitor c=6.50385e-19
    cc_520 (c_1607_n c_934_n) capacitor c=1.36001e-18
    cc_519 (c_1600_n c_933_n) capacitor c=3.03595e-19
    cc_518 (I6_MM2_g c_931_n) capacitor c=8.81172e-19
    cc_517 (I6_MM2_g c_944_p) capacitor c=3.00166e-18
    cc_516 (I6_MM2_g I6_MM2_d) capacitor c=2.19279e-18
    cc_515 (c_1468_n c_931_n) capacitor c=6.99769e-19
    cc_514 (c_1468_n c_944_p) capacitor c=2.37185e-18
    cc_513 (c_1468_n c_933_n) capacitor c=3.33597e-18
    cc_512 (c_1468_n I6_MM2_d) capacitor c=1.87569e-16
    cc_511 (c_1462_n I6_net15) capacitor c=2.66679e-16
    cc_510 (c_1462_n c_933_n) capacitor c=3.54601e-18
    cc_509 (I6_MM6_s c_931_n) capacitor c=9.46835e-19
    cc_508 (I6_MM6_s c_934_n) capacitor c=4.26802e-18
    cc_507 (I6_MM6_s c_933_n) capacitor c=2.33325e-18
    cc_506 (I6_MM6_s I6_MM2_d) capacitor c=3.01589e-17
    cc_505 (c_1254_n c_944_p) capacitor c=2.14991e-19
    cc_504 (c_1007_n c_931_n) capacitor c=7.67836e-18
    cc_503 (c_1007_n c_922_n) capacitor c=6.24311e-18
    cc_502 (c_1007_n I6_MM2_d) capacitor c=1.16626e-18
    cc_501 (c_1003_n I6_net15) capacitor c=2.56099e-17
    cc_500 (c_1003_n c_922_n) capacitor c=4.90889e-19
    cc_499 (c_1001_n c_922_n) capacitor c=3.88755e-18
    cc_498 (I6_MM1_g I6_net15) capacitor c=5.84791e-19
    cc_497 (I6_MM1_g c_922_n) capacitor c=6.33242e-19
    cc_496 (c_1293_n c_897_n) capacitor c=3.10347e-19
    cc_495 (c_1276_n c_904_n) capacitor c=2.5199e-17
    cc_494 (c_1276_n c_897_n) capacitor c=1.01553e-17
    cc_493 (c_1275_n c_899_n) capacitor c=1.91569e-16
    cc_492 (c_1275_n c_898_n) capacitor c=7.11884e-19
    cc_491 (c_1240_n c_896_n) capacitor c=1.57607e-18
    cc_490 (I6_MM7_s c_904_n) capacitor c=2.16559e-17
    cc_489 (I6_MM7_s c_897_n) capacitor c=4.964e-18
    cc_488 (I6_MM3_d c_899_n) capacitor c=3.72165e-17
    cc_487 (I6_MM3_d c_897_n) capacitor c=1.2939e-18
    cc_486 (I6_MM3_d c_896_n) capacitor c=4.56815e-18
    cc_485 (c_980_n c_899_n) capacitor c=1.106e-17
    cc_484 (c_980_n c_898_n) capacitor c=2.59529e-18
    cc_483 (I6_MM4_g c_899_n) capacitor c=6.83202e-19
    cc_482 (I6_MM4_g c_898_n) capacitor c=1.2772e-18
    cc_481 (c_1642_n c_851_n) capacitor c=3.2886e-19
    cc_480 (c_1609_n I5_net21) capacitor c=2.21455e-17
    cc_479 (c_1609_n c_851_n) capacitor c=2.27579e-19
    cc_478 (c_1609_n c_847_n) capacitor c=1.45482e-18
    cc_477 (c_1467_n c_866_n) capacitor c=4.5878e-19
    cc_476 (c_1467_n I5_I0_MM0_d) capacitor c=1.35029e-17
    cc_475 (I5_I0_MM0_s I5_I0_MM0_d) capacitor c=6.60732e-18
    cc_474 (c_1285_n c_845_n) capacitor c=4.06051e-18
    cc_473 (c_1252_n I5_net21) capacitor c=5.98259e-19
    cc_472 (c_1252_n c_845_n) capacitor c=3.88601e-18
    cc_471 (c_1252_n I5_I0_MM1_d) capacitor c=3.20838e-16
    cc_470 (c_1252_n I5_MM3_g) capacitor c=1.12429e-18
    cc_469 (I5_MM1_s c_845_n) capacitor c=2.16182e-18
    cc_468 (I5_MM1_s I5_MM3_g) capacitor c=1.33001e-18
    cc_467 (I5_I0_MM1_s c_845_n) capacitor c=8.46338e-19
    cc_466 (I5_I0_MM1_s I5_I0_MM1_d) capacitor c=4.54485e-17
    cc_465 (I5_MM2_d c_845_n) capacitor c=3.65244e-19
    cc_464 (c_1005_n c_845_n) capacitor c=3.74935e-18
    cc_463 (c_1004_n c_863_n) capacitor c=3.18874e-18
    cc_462 (c_1004_n c_857_n) capacitor c=8.47016e-19
    cc_461 (c_1004_n I5_I0_MM0_d) capacitor c=1.57027e-18
    cc_460 (c_1004_n I5_I0_MM1_d) capacitor c=3.05989e-18
    cc_459 (c_1018_n I5_I0_MM0_d) capacitor c=5.85475e-18
    cc_458 (c_1609_n c_794_n) capacitor c=3.22271e-19
    cc_457 (c_1609_n I6_MM6_g) capacitor c=3.55822e-18
    cc_456 (c_1607_n c_794_n) capacitor c=2.37924e-19
    cc_455 (c_1607_n c_790_n) capacitor c=8.32636e-18
    cc_454 (c_1607_n I6_MM6_g) capacitor c=4.47768e-18
    cc_453 (c_1603_n c_790_n) capacitor c=1.08345e-18
    cc_452 (c_1603_n c_835_p) capacitor c=9.73642e-18
    cc_451 (c_1629_n c_796_n) capacitor c=3.32446e-19
    cc_450 (c_1629_n c_829_p) capacitor c=9.97088e-18
    cc_449 (c_1629_n c_781_n) capacitor c=2.01139e-19
    cc_448 (c_1600_n c_796_n) capacitor c=1.9645e-18
    cc_447 (c_1600_n c_790_n) capacitor c=4.38721e-19
    cc_446 (c_1600_n c_829_p) capacitor c=5.22859e-16
    cc_445 (c_1600_n c_781_n) capacitor c=8.89227e-19
    cc_444 (c_1600_n I6_MM6_g) capacitor c=4.21975e-19
    cc_443 (I6_MM7_d c_796_n) capacitor c=5.84177e-18
    cc_442 (I6_MM7_d c_781_n) capacitor c=1.31921e-18
    cc_441 (I6_MM7_d I6_MM7_g) capacitor c=2.40734e-18
    cc_440 (I6_MM2_g I6_MM6_g) capacitor c=6.39389e-18
    cc_439 (c_1462_n c_794_n) capacitor c=2.23744e-18
    cc_438 (c_1462_n c_790_n) capacitor c=2.49719e-17
    cc_437 (I6_MM6_s I6_MM6_g) capacitor c=2.06958e-18
    cc_436 (c_1276_n c_782_n) capacitor c=3.69217e-19
    cc_435 (c_1275_n c_782_n) capacitor c=6.56372e-19
    cc_434 (c_1240_n c_780_n) capacitor c=2.50543e-18
    cc_433 (I6_MM7_s c_796_n) capacitor c=1.20392e-17
    cc_432 (I6_MM7_s I6_MM5_g) capacitor c=1.28969e-18
    cc_431 (I6_MM7_s c_781_n) capacitor c=1.12036e-18
    cc_430 (I6_MM7_s c_780_n) capacitor c=6.51906e-18
    cc_429 (I6_MM7_s I6_MM7_g) capacitor c=1.30655e-18
    cc_428 (c_992_n c_780_n) capacitor c=3.91642e-19
    cc_427 (I6_MM1_g c_794_n) capacitor c=2.86972e-18
    cc_426 (I6_MM1_g c_782_n) capacitor c=1.02763e-18
    cc_425 (I6_MM4_g c_782_n) capacitor c=5.03807e-19
    cc_424 (I6_MM4_g c_781_n) capacitor c=1.18106e-18
    cc_423 (I6_net15 c_782_n) capacitor c=3.94212e-19
    cc_422 (c_934_n I6_MM6_g) capacitor c=8.08638e-19
    cc_421 (c_933_n c_790_n) capacitor c=1.47288e-18
    cc_420 (c_922_n c_782_n) capacitor c=1.39377e-18
    cc_419 (c_899_n c_782_n) capacitor c=4.23085e-19
    cc_418 (c_898_n c_782_n) capacitor c=3.83098e-19
    cc_417 (c_904_n I6_MM5_g) capacitor c=2.69042e-18
    cc_416 (c_897_n c_796_n) capacitor c=3.00241e-19
    cc_415 (c_897_n c_782_n) capacitor c=6.3047e-19
    cc_414 (c_897_n I6_MM5_g) capacitor c=3.4201e-18
    cc_413 (c_1616_n c_738_n) capacitor c=2.81686e-19
    cc_412 (c_1616_n c_734_n) capacitor c=1.54897e-17
    cc_411 (c_1616_n c_730_n) capacitor c=8.22163e-19
    cc_410 (c_1467_n c_728_n) capacitor c=2.9273e-19
    cc_409 (c_1467_n c_743_p) capacitor c=2.89535e-19
    cc_408 (c_1467_n I5_I0_MM0_g) capacitor c=1.7121e-18
    cc_407 (I5_I0_MM0_s c_728_n) capacitor c=1.30955e-17
    cc_406 (I5_I0_MM0_s c_743_p) capacitor c=1.11305e-18
    cc_405 (I5_I0_MM0_s I5_I0_MM0_g) capacitor c=3.13577e-18
    cc_404 (c_1238_n c_728_n) capacitor c=3.25866e-19
    cc_403 (c_1238_n c_724_n) capacitor c=5.55175e-18
    cc_402 (c_1238_n c_743_p) capacitor c=2.02089e-19
    cc_401 (c_1238_n c_734_n) capacitor c=6.18423e-19
    cc_400 (c_1238_n I5_I0_MM1_g) capacitor c=1.70657e-18
    cc_399 (c_1238_n I5_MM1_g) capacitor c=1.16774e-18
    cc_398 (I5_MM1_s c_724_n) capacitor c=2.10003e-18
    cc_397 (I5_MM1_s I5_MM1_g) capacitor c=1.35261e-18
    cc_396 (I5_I0_MM1_s c_728_n) capacitor c=4.86126e-17
    cc_395 (I5_I0_MM1_s c_724_n) capacitor c=5.83133e-18
    cc_394 (I5_I0_MM1_s I5_I0_MM1_g) capacitor c=3.05129e-18
    cc_393 (c_1012_n I5_I0_MM0_g) capacitor c=2.94543e-19
    cc_392 (I5_net21 c_738_n) capacitor c=2.00147e-19
    cc_391 (I5_net21 c_734_n) capacitor c=5.37698e-18
    cc_390 (I5_net21 c_730_n) capacitor c=2.76692e-19
    cc_389 (c_851_n c_738_n) capacitor c=4.66867e-18
    cc_388 (c_847_n c_734_n) capacitor c=3.37497e-19
    cc_387 (c_847_n c_730_n) capacitor c=1.97619e-17
    cc_386 (c_866_n I5_I0_MM0_g) capacitor c=9.98816e-19
    cc_385 (c_863_n c_728_n) capacitor c=2.82765e-19
    cc_384 (c_863_n c_744_p) capacitor c=9.98816e-19
    cc_383 (c_863_n c_743_p) capacitor c=7.62531e-18
    cc_382 (c_845_n c_724_n) capacitor c=1.62011e-17
    cc_381 (c_845_n I5_I0_MM1_g) capacitor c=9.98816e-19
    cc_380 (c_860_n I5_I0_MM0_g) capacitor c=4.58982e-18
    cc_379 (c_857_n c_728_n) capacitor c=9.33936e-17
    cc_378 (c_857_n c_744_p) capacitor c=4.58982e-18
    cc_377 (c_857_n c_743_p) capacitor c=2.58392e-19
    cc_376 (I5_I0_MM1_d c_724_n) capacitor c=1.01721e-18
    cc_375 (I5_I0_MM1_d I5_I0_MM1_g) capacitor c=4.58982e-18
    cc_374 (I5_MM3_g I5_MM1_g) capacitor c=4.66867e-18
    cc_373 (c_1616_n c_680_p) capacitor c=1.16859e-18
    cc_372 (c_1609_n c_680_p) capacitor c=6.67901e-19
    cc_371 (c_1603_n c_678_n) capacitor c=5.53323e-19
    cc_370 (c_1603_n W_EN) capacitor c=8.5111e-19
    cc_369 (c_1603_n c_676_n) capacitor c=2.43653e-19
    cc_368 (c_1603_n c_680_p) capacitor c=1.26402e-18
    cc_367 (c_1254_n c_696_p) capacitor c=5.09889e-19
    cc_366 (c_1254_n c_695_p) capacitor c=4.75377e-19
    cc_365 (c_1254_n c_680_p) capacitor c=1.4194e-18
    cc_364 (c_1254_n I5_MM2_g) capacitor c=1.25398e-18
    cc_363 (c_1238_n c_680_p) capacitor c=7.10509e-19
    cc_362 (c_1252_n c_680_p) capacitor c=5.20469e-19
    cc_361 (I5_MM1_s c_680_p) capacitor c=7.40642e-19
    cc_360 (c_1007_n c_696_p) capacitor c=1.3679e-18
    cc_359 (c_1007_n c_697_p) capacitor c=5.55329e-19
    cc_358 (c_1007_n c_695_p) capacitor c=8.19097e-18
    cc_357 (c_1007_n c_694_p) capacitor c=6.48889e-19
    cc_356 (c_1007_n I5_MM2_g) capacitor c=1.21082e-18
    cc_355 (I5_MM2_d I5_MM2_g) capacitor c=2.63708e-18
    cc_354 (c_1005_n I5_MM2_g) capacitor c=1.12392e-18
    cc_353 (c_1004_n I5_MM2_g) capacitor c=3.07594e-19
    cc_352 (c_931_n c_695_p) capacitor c=6.42096e-19
    cc_351 (I6_MM2_d c_696_p) capacitor c=7.65353e-19
    cc_350 (I5_net21 c_696_p) capacitor c=1.42523e-17
    cc_349 (I5_net21 c_695_p) capacitor c=2.5748e-19
    cc_348 (c_851_n c_697_p) capacitor c=2.4736e-18
    cc_347 (c_847_n c_696_p) capacitor c=2.97787e-19
    cc_346 (c_847_n c_695_p) capacitor c=4.62991e-18
    cc_345 (c_847_n c_694_p) capacitor c=2.23555e-19
    cc_344 (c_847_n c_680_p) capacitor c=5.88244e-18
    cc_343 (c_845_n c_680_p) capacitor c=2.45828e-18
    cc_342 (c_845_n I5_MM2_g) capacitor c=4.40578e-19
    cc_341 (I5_MM3_g I5_MM2_g) capacitor c=7.66617e-18
    cc_340 (c_738_n c_676_n) capacitor c=2.4736e-18
    cc_339 (c_738_n c_680_p) capacitor c=3.59367e-19
    cc_338 (c_724_n c_680_p) capacitor c=2.50283e-18
    cc_337 (c_724_n I5_MM0_g) capacitor c=5.24276e-19
    cc_336 (c_734_n c_678_n) capacitor c=2.5748e-19
    cc_335 (c_734_n W_EN) capacitor c=1.42523e-17
    cc_334 (c_730_n c_678_n) capacitor c=4.58478e-18
    cc_333 (c_730_n W_EN) capacitor c=2.8762e-19
    cc_332 (c_730_n c_675_n) capacitor c=2.17391e-19
    cc_331 (c_730_n c_680_p) capacitor c=4.51408e-18
    cc_330 (I5_MM1_g I5_MM0_g) capacitor c=7.45961e-18
    cc_329 (I0_net13 BL) capacitor c=6.44557e-19
    cc_328 (c_387_n BL) capacitor c=2.60462e-18
    cc_327 (c_386_n BL) capacitor c=5.6995e-19
    cc_326 (c_385_n BL) capacitor c=1.11582e-18
    cc_325 (I0_MM6_g BL) capacitor c=3.06122e-18
    cc_324 (I0_MM4_g BL) capacitor c=4.82993e-18
    cc_323 (I0_MM2_s c_521_p) capacitor c=9.55348e-19
    cc_322 (c_331_n BL) capacitor c=9.29361e-18
    cc_321 (c_339_n BL) capacitor c=1.87815e-18
    cc_320 (I0_MM4_d BL) capacitor c=6.76935e-18
    cc_319 (c_337_n BL) capacitor c=1.70405e-18
    cc_318 (c_336_n BL) capacitor c=4.28501e-18
    cc_317 (c_335_n BL) capacitor c=4.04207e-18
    cc_316 (I0_MM2_s BL) capacitor c=4.98068e-18
    cc_315 (c_333_n BL) capacitor c=1.26634e-17
    cc_314 (c_332_n BL) capacitor c=2.84778e-18
    cc_313 (c_331_n c_499_p) capacitor c=1.21068e-18
    cc_312 (I0_MM2_s c_538_p) capacitor c=3.71859e-17
    cc_311 (I1_net13 c_533_p) capacitor c=6.44557e-19
    cc_310 (c_277_n c_533_p) capacitor c=2.60462e-18
    cc_309 (c_276_n c_533_p) capacitor c=5.6995e-19
    cc_308 (c_275_n c_533_p) capacitor c=1.11582e-18
    cc_307 (I1_MM6_g c_533_p) capacitor c=3.06122e-18
    cc_306 (I1_MM4_g c_533_p) capacitor c=4.82993e-18
    cc_305 (c_230_n c_533_p) capacitor c=9.27309e-18
    cc_304 (c_229_n c_533_p) capacitor c=1.87815e-18
    cc_303 (I1_MM4_d c_533_p) capacitor c=6.76935e-18
    cc_302 (c_227_n c_533_p) capacitor c=1.70405e-18
    cc_301 (c_226_n c_533_p) capacitor c=4.28501e-18
    cc_300 (c_225_n c_533_p) capacitor c=4.04207e-18
    cc_299 (I1_MM2_s c_533_p) capacitor c=4.98068e-18
    cc_298 (c_223_n c_533_p) capacitor c=1.26634e-17
    cc_297 (c_222_n c_533_p) capacitor c=2.84778e-18
    cc_296 (I1_MM2_s c_520_p) capacitor c=9.55348e-19
    cc_295 (I1_MM2_s c_534_p) capacitor c=3.71859e-17
    cc_294 (I2_net13 c_533_p) capacitor c=6.44557e-19
    cc_293 (c_166_n c_533_p) capacitor c=2.60462e-18
    cc_292 (c_165_n c_533_p) capacitor c=5.6995e-19
    cc_291 (c_164_n c_533_p) capacitor c=1.11582e-18
    cc_290 (I2_MM6_g c_533_p) capacitor c=3.06122e-18
    cc_289 (I2_MM4_g c_533_p) capacitor c=4.82993e-18
    cc_288 (c_119_n c_533_p) capacitor c=9.27309e-18
    cc_287 (c_118_n c_533_p) capacitor c=1.87815e-18
    cc_286 (I2_MM4_d c_533_p) capacitor c=6.76935e-18
    cc_285 (c_116_n c_533_p) capacitor c=1.70405e-18
    cc_284 (c_115_n c_533_p) capacitor c=4.28501e-18
    cc_283 (c_114_n c_533_p) capacitor c=4.04207e-18
    cc_282 (I2_MM2_s c_533_p) capacitor c=4.98068e-18
    cc_281 (c_112_n c_533_p) capacitor c=1.26634e-17
    cc_280 (c_111_n c_533_p) capacitor c=2.84778e-18
    cc_279 (I2_MM2_s c_519_p) capacitor c=9.55348e-19
    cc_278 (I2_MM2_s c_530_p) capacitor c=3.71859e-17
    cc_277 (I3_net13 c_528_p) capacitor c=6.44557e-19
    cc_276 (c_57_n c_528_p) capacitor c=2.60462e-18
    cc_275 (c_56_n c_528_p) capacitor c=5.6995e-19
    cc_274 (c_55_n c_528_p) capacitor c=1.11582e-18
    cc_273 (I3_MM6_g c_528_p) capacitor c=3.06122e-18
    cc_272 (I3_MM4_g c_528_p) capacitor c=4.82993e-18
    cc_271 (c_2_n c_528_p) capacitor c=9.74015e-18
    cc_270 (c_11_n c_528_p) capacitor c=1.87815e-18
    cc_269 (I3_MM4_d c_528_p) capacitor c=5.47105e-18
    cc_268 (c_9_n c_528_p) capacitor c=1.70405e-18
    cc_267 (c_8_n c_528_p) capacitor c=4.28501e-18
    cc_266 (c_7_n c_528_p) capacitor c=4.04207e-18
    cc_265 (I3_MM2_s c_528_p) capacitor c=4.94896e-18
    cc_264 (c_5_n c_528_p) capacitor c=1.26634e-17
    cc_263 (c_4_n c_528_p) capacitor c=2.84778e-18
    cc_262 (I3_MM2_s c_518_p) capacitor c=9.55348e-19
    cc_261 (c_2_n c_445_p) capacitor c=1.15775e-18
    cc_260 (I3_MM2_s c_526_p) capacitor c=3.71859e-17
    cc_259 (c_1773_n c_533_p) capacitor c=3.76401e-18
    cc_258 (c_1773_n c_520_p) capacitor c=8.81173e-19
    cc_257 (c_1773_n c_534_p) capacitor c=2.18352e-18
    cc_256 (c_1747_n c_533_p) capacitor c=3.76401e-18
    cc_255 (c_1747_n c_519_p) capacitor c=8.81173e-19
    cc_254 (c_1747_n c_530_p) capacitor c=2.18352e-18
    cc_253 (c_1721_n c_528_p) capacitor c=3.76401e-18
    cc_252 (c_1721_n c_518_p) capacitor c=8.81173e-19
    cc_251 (c_1721_n c_526_p) capacitor c=2.18352e-18
    cc_250 (c_1694_n c_521_p) capacitor c=8.81173e-19
    cc_249 (c_1694_n BL) capacitor c=3.76401e-18
    cc_248 (c_1694_n c_538_p) capacitor c=2.18352e-18
    cc_247 (c_1670_n I4_MM2\@2_d) capacitor c=5.34052e-19
    cc_246 (c_1669_n I4_MM2\@2_d) capacitor c=9.40836e-19
    cc_245 (c_1667_n I4_MM2\@2_d) capacitor c=5.17597e-19
    cc_244 (c_1667_n c_496_p) capacitor c=3.11854e-18
    cc_243 (c_1665_n BL) capacitor c=4.629e-18
    cc_242 (c_1665_n c_499_p) capacitor c=2.34024e-18
    cc_241 (c_1609_n c_440_p) capacitor c=4.8563e-19
    cc_240 (c_1609_n c_465_p) capacitor c=6.79545e-19
    cc_239 (c_1608_n c_440_p) capacitor c=3.6216e-18
    cc_238 (c_1607_n c_440_p) capacitor c=4.74707e-19
    cc_237 (c_1604_n c_440_p) capacitor c=4.09168e-18
    cc_236 (c_1604_n I5_MM0_d) capacitor c=6.19675e-19
    cc_235 (c_1604_n c_438_p) capacitor c=3.11027e-19
    cc_234 (c_1603_n c_454_p) capacitor c=1.1422e-18
    cc_233 (c_1600_n c_440_p) capacitor c=1.60117e-17
    cc_232 (c_1600_n c_574_p) capacitor c=1.83539e-18
    cc_231 (c_1600_n c_454_p) capacitor c=4.01583e-18
    cc_230 (I6_MM2_g I6_MM0_g) capacitor c=1.05154e-18
    cc_229 (c_1468_n c_503_p) capacitor c=7.91285e-19
    cc_228 (c_1468_n I6_MM0_g) capacitor c=4.81892e-19
    cc_227 (c_1467_n c_528_p) capacitor c=6.68472e-18
    cc_226 (c_1465_n c_496_p) capacitor c=2.8806e-19
    cc_225 (c_1465_n BL) capacitor c=6.31295e-18
    cc_224 (c_1464_n c_533_p) capacitor c=6.29615e-18
    cc_223 (c_1462_n c_440_p) capacitor c=3.83144e-19
    cc_222 (c_1462_n c_465_p) capacitor c=8.35899e-19
    cc_221 (I6_MM6_s c_440_p) capacitor c=2.35075e-19
    cc_220 (I4_MM0_s BL) capacitor c=3.27217e-18
    cc_219 (I4_MM0_s c_499_p) capacitor c=2.35498e-17
    cc_218 (I0_MM6_s BL) capacitor c=3.96976e-18
    cc_217 (I1_MM6_s c_533_p) capacitor c=3.5739e-18
    cc_216 (I2_MM6_s c_533_p) capacitor c=3.5739e-18
    cc_215 (I3_MM6_s c_528_p) capacitor c=3.5739e-18
    cc_214 (I5_I0_MM0_s c_445_p) capacitor c=7.09807e-18
    cc_213 (c_1246_n c_537_p) capacitor c=1.00077e-17
    cc_212 (c_1246_n c_521_p) capacitor c=2.06212e-19
    cc_211 (c_1246_n c_520_p) capacitor c=2.06212e-19
    cc_210 (c_1246_n c_538_p) capacitor c=4.97278e-16
    cc_209 (c_1246_n c_534_p) capacitor c=4.97278e-16
    cc_208 (c_1241_n c_529_p) capacitor c=1.00077e-17
    cc_207 (c_1241_n c_519_p) capacitor c=2.06212e-19
    cc_206 (c_1241_n c_518_p) capacitor c=2.06212e-19
    cc_205 (c_1241_n c_530_p) capacitor c=4.97278e-16
    cc_204 (c_1241_n c_526_p) capacitor c=4.97278e-16
    cc_203 (c_1240_n I6_MM3_g) capacitor c=3.87852e-19
    cc_202 (c_1238_n c_445_p) capacitor c=3.32044e-19
    cc_201 (c_1238_n c_446_p) capacitor c=2.34819e-18
    cc_200 (I5_MM1_s I5_MM0_d) capacitor c=1.07926e-18
    cc_199 (I0_MM4_s c_537_p) capacitor c=1.63622e-18
    cc_198 (I0_MM4_s c_521_p) capacitor c=2.85137e-19
    cc_197 (I0_MM4_s BL) capacitor c=6.62447e-18
    cc_196 (I0_MM4_s c_538_p) capacitor c=5.7189e-17
    cc_195 (I1_MM4_s c_537_p) capacitor c=1.63622e-18
    cc_194 (I1_MM4_s c_533_p) capacitor c=6.62447e-18
    cc_193 (I1_MM4_s c_520_p) capacitor c=2.85137e-19
    cc_192 (I1_MM4_s c_534_p) capacitor c=5.7189e-17
    cc_191 (I2_MM4_s c_533_p) capacitor c=6.62447e-18
    cc_190 (I2_MM4_s c_529_p) capacitor c=1.63622e-18
    cc_189 (I2_MM4_s c_519_p) capacitor c=2.85137e-19
    cc_188 (I2_MM4_s c_530_p) capacitor c=5.7189e-17
    cc_187 (I3_MM4_s c_529_p) capacitor c=1.63622e-18
    cc_186 (I3_MM4_s c_528_p) capacitor c=6.62447e-18
    cc_185 (I3_MM4_s c_518_p) capacitor c=2.85137e-19
    cc_184 (I3_MM4_s c_526_p) capacitor c=5.7189e-17
    cc_183 (I5_I0_MM1_s c_446_p) capacitor c=1.30442e-18
    cc_182 (c_1003_n I6_MM0_g) capacitor c=2.36129e-18
    cc_181 (c_1001_n I6_MM1_d) capacitor c=2.67558e-19
    cc_180 (c_1001_n I6_MM0_g) capacitor c=3.92308e-19
    cc_179 (c_1000_n c_521_p) capacitor c=1.35676e-18
    cc_178 (c_999_n c_520_p) capacitor c=1.35676e-18
    cc_177 (c_998_n c_519_p) capacitor c=1.35676e-18
    cc_176 (c_997_n c_518_p) capacitor c=1.35676e-18
    cc_175 (I4_MM1_d BL) capacitor c=1.09243e-18
    cc_174 (c_995_n I6_MM3_g) capacitor c=2.20837e-18
    cc_173 (c_992_n c_503_p) capacitor c=4.24696e-19
    cc_172 (c_992_n c_465_p) capacitor c=1.08148e-17
    cc_171 (c_992_n c_485_p) capacitor c=2.37388e-17
    cc_170 (c_988_n I6_MM1_d) capacitor c=7.96847e-19
    cc_169 (c_988_n c_456_p) capacitor c=2.671e-19
    cc_168 (c_988_n c_503_p) capacitor c=2.37445e-17
    cc_167 (c_988_n I6_MM3_g) capacitor c=4.41349e-18
    cc_166 (I6_MM3_d c_485_p) capacitor c=9.93017e-19
    cc_165 (I6_MM3_d I6_MM3_g) capacitor c=3.51226e-18
    cc_164 (I4_MM2_s I4_MM2\@2_d) capacitor c=2.35556e-17
    cc_163 (I4_MM2_s c_497_p) capacitor c=1.20196e-18
    cc_162 (I4_MM2_s BL) capacitor c=7.32613e-19
    cc_161 (c_980_n c_503_p) capacitor c=1.0746e-17
    cc_160 (c_980_n c_465_p) capacitor c=5.40727e-18
    cc_159 (c_980_n I6_MM3_g) capacitor c=5.53482e-18
    cc_158 (c_978_n BL) capacitor c=2.57709e-18
    cc_157 (c_978_n c_499_p) capacitor c=3.87042e-16
    cc_156 (c_974_n I4_MM2\@2_d) capacitor c=1.18872e-16
    cc_155 (c_974_n c_497_p) capacitor c=7.06719e-19
    cc_154 (c_974_n c_496_p) capacitor c=1.17023e-18
    cc_153 (c_974_n BL) capacitor c=2.27756e-18
    cc_152 (I4_MM2\@2_s I4_MM2\@2_d) capacitor c=4.43544e-17
    cc_151 (I4_MM2\@2_s c_493_p) capacitor c=4.59196e-18
    cc_150 (I4_MM2\@2_s BL) capacitor c=6.33704e-18
    cc_149 (I6_MM1_g I6_MM1_d) capacitor c=3.108e-18
    cc_148 (I6_MM1_g c_456_p) capacitor c=1.21801e-18
    cc_147 (I6_MM1_g c_489_p) capacitor c=2.20837e-18
    cc_146 (I6_MM1_g c_465_p) capacitor c=5.94898e-18
    cc_145 (I6_MM1_g I6_MM0_g) capacitor c=6.64034e-18
    cc_144 (I6_MM1_g I6_MM3_g) capacitor c=1.2535e-18
    cc_143 (I6_MM4_g c_485_p) capacitor c=4.4333e-18
    cc_142 (I6_MM4_g c_452_p) capacitor c=2.3733e-18
    cc_141 (I6_MM4_g I6_MM3_g) capacitor c=6.58584e-18
    cc_140 (I6_net15 I6_MM1_d) capacitor c=2.95979e-17
    cc_139 (I6_net15 c_456_p) capacitor c=2.86462e-19
    cc_138 (I6_net15 c_465_p) capacitor c=1.86814e-16
    cc_137 (I6_net15 I6_MM0_g) capacitor c=5.33787e-19
    cc_136 (c_922_n I6_MM1_d) capacitor c=2.3951e-19
    cc_135 (c_922_n c_456_p) capacitor c=5.05328e-18
    cc_134 (c_922_n c_465_p) capacitor c=9.48022e-19
    cc_133 (c_922_n I6_MM0_g) capacitor c=3.60119e-19
    cc_132 (c_899_n c_452_p) capacitor c=1.88922e-17
    cc_131 (c_899_n I6_MM3_g) capacitor c=9.35298e-19
    cc_130 (c_898_n c_452_p) capacitor c=1.83786e-18
    cc_129 (c_897_n I6_MM3_g) capacitor c=4.36451e-19
    cc_128 (c_896_n I6_MM3_g) capacitor c=3.08884e-18
    cc_127 (I5_I0_MM0_d c_445_p) capacitor c=8.41458e-19
    cc_126 (I5_I0_MM0_d c_446_p) capacitor c=1.10466e-18
    cc_125 (c_796_n c_452_p) capacitor c=1.57278e-17
    cc_124 (c_794_n I6_MM1_d) capacitor c=3.66803e-19
    cc_123 (c_794_n c_465_p) capacitor c=3.72549e-19
    cc_122 (c_790_n I6_MM1_d) capacitor c=4.48895e-17
    cc_121 (c_790_n c_456_p) capacitor c=6.03407e-19
    cc_120 (c_790_n c_454_p) capacitor c=2.6996e-19
    cc_119 (c_790_n c_461_p) capacitor c=3.44645e-19
    cc_118 (c_789_n c_454_p) capacitor c=1.44506e-18
    cc_117 (c_787_n c_454_p) capacitor c=3.83778e-19
    cc_116 (c_787_n c_452_p) capacitor c=2.1175e-18
    cc_115 (c_782_n I6_MM1_d) capacitor c=1.30033e-16
    cc_114 (c_782_n c_456_p) capacitor c=1.00729e-18
    cc_113 (c_782_n c_440_p) capacitor c=1.64345e-18
    cc_112 (c_782_n c_454_p) capacitor c=5.34879e-18
    cc_111 (c_782_n c_452_p) capacitor c=7.38453e-17
    cc_110 (c_781_n c_452_p) capacitor c=2.9556e-19
    cc_109 (c_780_n I6_MM3_g) capacitor c=1.18106e-18
    cc_108 (c_728_n c_446_p) capacitor c=8.68598e-19
    cc_107 (c_724_n c_440_p) capacitor c=2.34681e-18
    cc_106 (c_724_n I5_MM0_d) capacitor c=4.26925e-19
    cc_105 (c_724_n c_438_p) capacitor c=4.20963e-18
    cc_104 (c_724_n c_446_p) capacitor c=1.49206e-17
    cc_103 (I5_I0_MM0_g c_445_p) capacitor c=4.27648e-19
    cc_102 (c_678_n c_440_p) capacitor c=8.18355e-18
    cc_101 (W_EN c_440_p) capacitor c=1.3679e-18
    cc_100 (c_676_n c_440_p) capacitor c=5.55329e-19
    cc_99 (c_675_n c_440_p) capacitor c=5.40934e-19
    cc_98 (I5_MM0_g c_440_p) capacitor c=7.18639e-19
    cc_97 (I5_MM0_g I5_MM0_d) capacitor c=2.62957e-18
    cc_96 (I5_MM0_g c_438_p) capacitor c=1.10111e-18
    cc_95 (I0_net13 c_333_n) capacitor c=1.06362e-18
    cc_94 (I0_MM7_d I0_MM7_g) capacitor c=2.34013e-18
    cc_93 (c_397_n I0_MM5_g) capacitor c=2.77228e-18
    cc_92 (c_387_n c_336_n) capacitor c=3.76888e-18
    cc_91 (c_387_n c_333_n) capacitor c=5.29498e-16
    cc_90 (c_386_n c_333_n) capacitor c=3.31324e-19
    cc_89 (c_386_n I0_MM7_g) capacitor c=1.11651e-18
    cc_88 (c_385_n c_336_n) capacitor c=1.91586e-16
    cc_87 (c_385_n c_332_n) capacitor c=3.31324e-19
    cc_86 (c_385_n I0_MM5_g) capacitor c=5.07134e-18
    cc_85 (c_392_n c_337_n) capacitor c=1.15375e-17
    cc_84 (c_392_n c_336_n) capacitor c=2.19279e-18
    cc_83 (c_392_n I0_MM7_g) capacitor c=5.7092e-18
    cc_82 (I0_MM6_g c_331_n) capacitor c=2.34362e-18
    cc_81 (I0_MM6_g c_333_n) capacitor c=1.15069e-18
    cc_80 (I0_MM4_g c_367_p) capacitor c=2.46679e-18
    cc_79 (I0_MM4_g c_337_n) capacitor c=3.78736e-19
    cc_78 (I0_MM4_g c_336_n) capacitor c=6.00873e-18
    cc_77 (I0_MM4_g c_335_n) capacitor c=2.76393e-18
    cc_76 (I0_MM4_g c_333_n) capacitor c=2.04603e-18
    cc_75 (I0_MM4_g c_332_n) capacitor c=1.03987e-18
    cc_74 (I0_MM4_g I0_MM7_g) capacitor c=9.81229e-18
    cc_73 (I0_MM4_g I0_MM5_g) capacitor c=8.0234e-18
    cc_72 (I1_net13 c_223_n) capacitor c=1.06362e-18
    cc_71 (I1_MM7_d I1_MM7_g) capacitor c=2.34013e-18
    cc_70 (c_277_n c_226_n) capacitor c=3.76888e-18
    cc_69 (c_277_n c_223_n) capacitor c=5.29498e-16
    cc_68 (c_276_n c_223_n) capacitor c=3.31324e-19
    cc_67 (c_276_n I1_MM7_g) capacitor c=1.11651e-18
    cc_66 (c_275_n c_227_n) capacitor c=1.91586e-16
    cc_65 (c_275_n c_222_n) capacitor c=3.31324e-19
    cc_64 (c_275_n I1_MM7_g) capacitor c=5.07134e-18
    cc_63 (c_281_n c_227_n) capacitor c=1.15375e-17
    cc_62 (c_281_n c_226_n) capacitor c=2.19279e-18
    cc_61 (c_281_n I1_MM7_g) capacitor c=5.69103e-18
    cc_60 (I1_MM5_d I1_MM5_g) capacitor c=2.77228e-18
    cc_59 (I1_MM6_g c_230_n) capacitor c=2.34362e-18
    cc_58 (I1_MM6_g c_223_n) capacitor c=1.15069e-18
    cc_57 (I1_MM6_g I1_MM7_g) capacitor c=9.81229e-18
    cc_56 (I1_MM4_g c_256_p) capacitor c=2.46679e-18
    cc_55 (I1_MM4_g I1_MM4_d) capacitor c=2.76393e-18
    cc_54 (I1_MM4_g c_227_n) capacitor c=3.78736e-19
    cc_53 (I1_MM4_g c_226_n) capacitor c=6.00873e-18
    cc_52 (I1_MM4_g c_223_n) capacitor c=2.04603e-18
    cc_51 (I1_MM4_g c_222_n) capacitor c=1.03987e-18
    cc_50 (I1_MM4_g I1_MM5_g) capacitor c=8.0234e-18
    cc_49 (I1_MM6_g I2_MM6_g) capacitor c=1.15308e-18
    cc_48 (c_230_n c_119_n) capacitor c=3.74444e-18
    cc_47 (I1_MM7_g I2_MM7_g) capacitor c=1.15308e-18
    cc_46 (I2_net13 c_112_n) capacitor c=1.06362e-18
    cc_45 (I2_MM7_d I2_MM7_g) capacitor c=2.34013e-18
    cc_44 (c_175_n I2_MM5_g) capacitor c=2.77228e-18
    cc_43 (c_166_n c_115_n) capacitor c=3.76888e-18
    cc_42 (c_166_n c_112_n) capacitor c=5.29498e-16
    cc_41 (c_165_n c_112_n) capacitor c=3.31324e-19
    cc_40 (c_165_n I2_MM7_g) capacitor c=1.11651e-18
    cc_39 (c_164_n c_115_n) capacitor c=1.91586e-16
    cc_38 (c_164_n c_111_n) capacitor c=3.31324e-19
    cc_37 (c_164_n I2_MM5_g) capacitor c=5.07134e-18
    cc_36 (c_170_n c_116_n) capacitor c=1.15375e-17
    cc_35 (c_170_n c_115_n) capacitor c=2.19279e-18
    cc_34 (c_170_n I2_MM7_g) capacitor c=5.69103e-18
    cc_33 (I2_MM6_g c_119_n) capacitor c=2.34362e-18
    cc_32 (I2_MM6_g c_112_n) capacitor c=1.15069e-18
    cc_31 (I2_MM4_g c_144_p) capacitor c=2.46679e-18
    cc_30 (I2_MM4_g c_116_n) capacitor c=3.78736e-19
    cc_29 (I2_MM4_g c_115_n) capacitor c=6.00873e-18
    cc_28 (I2_MM4_g c_114_n) capacitor c=2.76393e-18
    cc_27 (I2_MM4_g c_112_n) capacitor c=2.04603e-18
    cc_26 (I2_MM4_g c_111_n) capacitor c=1.03987e-18
    cc_25 (I2_MM4_g I2_MM7_g) capacitor c=9.81229e-18
    cc_24 (I2_MM4_g I2_MM5_g) capacitor c=8.0234e-18
    cc_23 (I3_net13 c_5_n) capacitor c=1.06362e-18
    cc_22 (I3_MM7_d I3_MM7_g) capacitor c=2.34013e-18
    cc_21 (c_57_n c_8_n) capacitor c=3.76888e-18
    cc_20 (c_57_n c_5_n) capacitor c=5.29498e-16
    cc_19 (c_56_n c_5_n) capacitor c=3.31324e-19
    cc_18 (c_56_n I3_MM7_g) capacitor c=1.11651e-18
    cc_17 (c_55_n c_9_n) capacitor c=1.91586e-16
    cc_16 (c_55_n c_4_n) capacitor c=3.31324e-19
    cc_15 (c_55_n I3_MM7_g) capacitor c=5.07134e-18
    cc_14 (c_61_n c_9_n) capacitor c=1.15375e-17
    cc_13 (c_61_n c_8_n) capacitor c=2.19279e-18
    cc_12 (c_61_n I3_MM7_g) capacitor c=5.69103e-18
    cc_11 (I3_MM5_d I3_MM5_g) capacitor c=2.77228e-18
    cc_10 (I3_MM6_g c_2_n) capacitor c=2.34362e-18
    cc_9 (I3_MM6_g c_5_n) capacitor c=1.15069e-18
    cc_8 (I3_MM6_g I3_MM7_g) capacitor c=9.81229e-18
    cc_7 (I3_MM4_g c_36_p) capacitor c=2.46679e-18
    cc_6 (I3_MM4_g I3_MM4_d) capacitor c=2.76393e-18
    cc_5 (I3_MM4_g c_9_n) capacitor c=3.78736e-19
    cc_4 (I3_MM4_g c_8_n) capacitor c=6.00873e-18
    cc_3 (I3_MM4_g c_5_n) capacitor c=2.04603e-18
    cc_2 (I3_MM4_g c_4_n) capacitor c=1.03987e-18
    cc_1 (I3_MM4_g I3_MM5_g) capacitor c=8.0234e-18
    ciWL1_28 (_net0 c_1776_n) capacitor c=7.29513e-18
    ciWL1_27 (_net0 c_1773_n) capacitor c=3.90785e-17
    ciWL1_26 (_net0 WL1) capacitor c=4.36433e-18
    ciWL2_28 (_net0 c_1750_n) capacitor c=7.29513e-18
    ciWL2_27 (_net0 c_1747_n) capacitor c=3.908e-17
    ciWL2_26 (_net0 c_1754_n) capacitor c=4.39737e-18
    ciWL3_28 (_net0 c_1724_n) capacitor c=7.29513e-18
    ciWL3_27 (_net0 c_1721_n) capacitor c=3.90791e-17
    ciWL3_26 (_net0 c_1728_n) capacitor c=4.37669e-18
    ciWL0_29 (_net0 c_1697_n) capacitor c=7.29513e-18
    ciWL0_28 (_net0 c_1694_n) capacitor c=3.90785e-17
    ciWL0_27 (_net0 c_1701_n) capacitor c=4.3654e-18
    ciPRE_B_38 (_net0 c_1665_n) capacitor c=1.50825e-17
    ciPRE_B_37 (_net0 c_1667_n) capacitor c=1.14925e-17
    ciPRE_B_36 (_net0 c_1669_n) capacitor c=4.1224e-18
    ciPRE_B_35 (_net0 c_1674_n) capacitor c=1.49306e-17
    ciPRE_B_34 (_net0 c_1670_n) capacitor c=1.21068e-17
    ciPRE_B_33 (_net0 c_1678_n) capacitor c=2.11765e-18
    ciPRE_B_32 (_net0 c_1680_n) capacitor c=4.48018e-19
    ciPRE_B_31 (_net0 PRE_B) capacitor c=4.65124e-18
    ciPRE_B_30 (_net0 c_1690_n) capacitor c=6.92649e-18
    ciPRE_B_29 (_net0 c_1682_n) capacitor c=9.13276e-18
    ciXI6_net25_77 (_net0 I6_MM2_g) capacitor c=1.40041e-17
    ciXI6_net25_76 (_net0 I6_MM7_d) capacitor c=4.7829e-18
    ciXI6_net25_75 (_net0 c_1600_n) capacitor c=4.30672e-17
    ciXI6_net25_74 (_net0 c_1629_n) capacitor c=9.89574e-18
    ciXI6_net25_73 (_net0 I6_net25_18) capacitor c=4.31713e-18
    ciXI6_net25_72 (_net0 c_1603_n) capacitor c=8.17073e-18
    ciXI6_net25_71 (_net0 c_1604_n) capacitor c=2.36696e-18
    ciXI6_net25_70 (_net0 c_1607_n) capacitor c=2.10257e-18
    ciXI6_net25_69 (_net0 c_1608_n) capacitor c=3.16453e-18
    ciXI6_net25_68 (_net0 c_1609_n) capacitor c=7.96021e-18
    ciXI6_net25_67 (_net0 c_1616_n) capacitor c=3.1325e-18
    ciXI6_net25_66 (_net0 c_1642_n) capacitor c=7.0207e-18
    civdd_161 (_net0 I5_I0_MM0_s) capacitor c=8.34195e-18
    civdd_160 (_net0 I3_MM6_s) capacitor c=4.22299e-18
    civdd_159 (_net0 I2_MM6_s) capacitor c=4.23632e-18
    civdd_158 (_net0 I1_MM6_s) capacitor c=4.13473e-18
    civdd_157 (_net0 I0_MM6_s) capacitor c=5.05029e-18
    civdd_156 (_net0 I4_MM0_s) capacitor c=3.51935e-18
    civdd_155 (_net0 I6_MM6_s) capacitor c=4.84553e-18
    civdd_154 (_net0 c_1462_n) capacitor c=2.92053e-18
    civdd_153 (_net0 c_1501_n) capacitor c=5.77242e-17
    civdd_152 (_net0 c_1464_n) capacitor c=1.28544e-17
    civdd_151 (_net0 c_1503_n) capacitor c=6.39142e-17
    civdd_150 (_net0 c_1465_n) capacitor c=1.2255e-17
    civdd_149 (_net0 c_1508_n) capacitor c=5.51318e-17
    civdd_148 (_net0 c_1467_n) capacitor c=1.24173e-17
    civdd_147 (_net0 c_1528_n) capacitor c=3.18979e-16
    civdd_146 (_net0 c_1533_n) capacitor c=3.8227e-17
    civdd_145 (_net0 c_1468_n) capacitor c=4.68313e-17
    cignd_261 (_net0 I5_I0_MM1_s) capacitor c=6.50396e-18
    cignd_260 (_net0 I3_MM4_s) capacitor c=1.27106e-17
    cignd_259 (_net0 I2_MM4_s) capacitor c=1.28182e-17
    cignd_258 (_net0 I1_MM4_s) capacitor c=1.27422e-17
    cignd_257 (_net0 I0_MM4_s) capacitor c=1.28182e-17
    cignd_256 (_net0 I5_MM1_s) capacitor c=4.93397e-18
    cignd_255 (_net0 c_1312_n) capacitor c=5.61522e-18
    cignd_254 (_net0 c_1315_n) capacitor c=5.61522e-18
    cignd_253 (_net0 c_1252_n) capacitor c=2.58987e-18
    cignd_252 (_net0 c_1238_n) capacitor c=1.0485e-17
    cignd_251 (_net0 I6_MM7_s) capacitor c=6.15698e-18
    cignd_250 (_net0 c_1240_n) capacitor c=4.53411e-18
    cignd_249 (_net0 c_1275_n) capacitor c=1.70131e-18
    cignd_248 (_net0 c_1285_n) capacitor c=3.12117e-18
    cignd_247 (_net0 c_1321_n) capacitor c=2.84828e-18
    cignd_246 (_net0 c_1322_n) capacitor c=2.20363e-18
    cignd_245 (_net0 c_1276_n) capacitor c=4.71746e-18
    cignd_244 (_net0 c_1241_n) capacitor c=1.18902e-17
    cignd_243 (_net0 c_1246_n) capacitor c=1.19667e-17
    cignd_242 (_net0 c_1326_n) capacitor c=2.76028e-16
    cignd_241 (_net0 c_1293_n) capacitor c=3.44676e-18
    cignd_240 (_net0 c_1357_p) capacitor c=3.54682e-18
    cignd_239 (_net0 c_1346_p) capacitor c=2.35749e-17
    cignd_238 (_net0 c_1347_p) capacitor c=3.07649e-17
    cignd_237 (_net0 c_1335_n) capacitor c=8.29973e-17
    cignd_236 (_net0 c_1254_n) capacitor c=5.3083e-17
    cignd_235 (_net0 c_1341_n) capacitor c=2.52621e-17
    cignd_234 (_net0 c_1343_n) capacitor c=2.64687e-17
    ciBLB_292 (_net0 I3_MM3_d) capacitor c=5.15262e-18
    ciBLB_291 (_net0 I2_MM3_d) capacitor c=5.15277e-18
    ciBLB_290 (_net0 I1_MM3_d) capacitor c=5.15252e-18
    ciBLB_289 (_net0 I0_MM3_d) capacitor c=5.15252e-18
    ciBLB_288 (_net0 I6_MM4_g) capacitor c=1.46008e-17
    ciBLB_287 (_net0 I6_MM1_g) capacitor c=2.01745e-17
    ciBLB_286 (_net0 I4_MM2\@2_s) capacitor c=1.01196e-17
    ciBLB_285 (_net0 c_974_n) capacitor c=2.74781e-18
    ciBLB_284 (_net0 c_978_n) capacitor c=2.87195e-18
    ciBLB_283 (_net0 c_980_n) capacitor c=3.38652e-18
    ciBLB_282 (_net0 I4_MM2_s) capacitor c=6.74464e-18
    ciBLB_281 (_net0 I6_MM3_d) capacitor c=7.7778e-18
    ciBLB_280 (_net0 c_988_n) capacitor c=1.02357e-17
    ciBLB_279 (_net0 c_992_n) capacitor c=1.13716e-18
    ciBLB_278 (_net0 c_995_n) capacitor c=5.32688e-18
    ciBLB_277 (_net0 c_1127_p) capacitor c=7.9403e-19
    ciBLB_276 (_net0 c_1070_p) capacitor c=2.81229e-18
    ciBLB_275 (_net0 c_1012_n) capacitor c=3.27877e-17
    ciBLB_274 (_net0 c_1042_p) capacitor c=5.86065e-18
    ciBLB_273 (_net0 c_1046_p) capacitor c=5.1471e-17
    ciBLB_272 (_net0 c_1050_p) capacitor c=5.79152e-18
    ciBLB_271 (_net0 c_1054_p) capacitor c=3.51968e-17
    ciBLB_270 (_net0 I4_MM1_d) capacitor c=6.43362e-18
    ciBLB_269 (_net0 c_1107_p) capacitor c=1.1643e-17
    ciBLB_268 (_net0 c_1018_n) capacitor c=4.00964e-18
    ciBLB_267 (_net0 c_1004_n) capacitor c=1.83446e-17
    ciBLB_266 (_net0 c_997_n) capacitor c=4.35428e-18
    ciBLB_265 (_net0 c_998_n) capacitor c=4.35519e-18
    ciBLB_264 (_net0 c_999_n) capacitor c=4.35493e-18
    ciBLB_263 (_net0 c_1000_n) capacitor c=4.35493e-18
    ciBLB_262 (_net0 c_1001_n) capacitor c=7.86715e-18
    ciBLB_261 (_net0 c_1003_n) capacitor c=4.45137e-18
    ciBLB_260 (_net0 c_1005_n) capacitor c=5.19533e-18
    ciBLB_259 (_net0 I5_MM2_d) capacitor c=5.1526e-18
    ciBLB_258 (_net0 c_1007_n) capacitor c=1.80129e-17
    ciXI6_net15_46 (_net0 I6_MM2_d) capacitor c=5.43059e-18
    ciXI6_net15_45 (_net0 c_922_n) capacitor c=3.38927e-18
    ciXI6_net15_44 (_net0 c_933_n) capacitor c=7.9865e-18
    ciXI6_net15_43 (_net0 c_944_p) capacitor c=2.70784e-18
    ciXI6_net15_42 (_net0 c_934_n) capacitor c=2.09662e-18
    ciXI6_net15_41 (_net0 c_931_n) capacitor c=4.76671e-18
    ciXI6_net15_40 (_net0 I6_net15) capacitor c=5.20785e-18
    ciXI6_net17_30 (_net0 c_896_n) capacitor c=5.06413e-18
    ciXI6_net17_29 (_net0 c_897_n) capacitor c=1.70464e-17
    ciXI6_net17_28 (_net0 c_904_n) capacitor c=5.51266e-18
    ciXI6_net17_27 (_net0 c_898_n) capacitor c=5.38581e-18
    ciXI6_net17_26 (_net0 c_899_n) capacitor c=5.84697e-18
    ciXI5_net21_65 (_net0 I5_MM3_g) capacitor c=1.08651e-17
    ciXI5_net21_64 (_net0 I5_I0_MM1_d) capacitor c=7.12027e-18
    ciXI5_net21_63 (_net0 I5_I0_MM0_d) capacitor c=9.13897e-18
    ciXI5_net21_62 (_net0 c_857_n) capacitor c=1.10392e-18
    ciXI5_net21_61 (_net0 c_860_n) capacitor c=1.10918e-18
    ciXI5_net21_60 (_net0 c_845_n) capacitor c=1.11158e-17
    ciXI5_net21_59 (_net0 c_863_n) capacitor c=6.83108e-19
    ciXI5_net21_58 (_net0 c_866_n) capacitor c=1.61355e-18
    ciXI5_net21_57 (_net0 I5_net21_30) capacitor c=1.724e-18
    ciXI5_net21_56 (_net0 c_847_n) capacitor c=3.83994e-18
    ciXI5_net21_55 (_net0 c_851_n) capacitor c=5.09556e-18
    ciXI5_net21_54 (_net0 I5_net21) capacitor c=2.23303e-18
    ciSE_74 (_net0 I6_MM7_g) capacitor c=1.23728e-17
    ciSE_73 (_net0 I6_MM6_g) capacitor c=2.01723e-17
    ciSE_72 (_net0 c_780_n) capacitor c=9.16785e-18
    ciSE_71 (_net0 c_781_n) capacitor c=1.61553e-17
    ciSE_70 (_net0 I6_MM5_g) capacitor c=1.23728e-17
    ciSE_69 (_net0 c_782_n) capacitor c=2.10826e-17
    ciSE_68 (_net0 c_787_n) capacitor c=2.56634e-18
    ciSE_67 (_net0 c_829_p) capacitor c=1.77014e-18
    ciSE_66 (_net0 c_789_n) capacitor c=2.46202e-18
    ciSE_65 (_net0 c_835_p) capacitor c=1.67323e-18
    ciSE_64 (_net0 c_790_n) capacitor c=2.43658e-18
    ciSE_63 (_net0 c_794_n) capacitor c=1.25933e-17
    ciSE_62 (_net0 c_796_n) capacitor c=3.43602e-18
    ciD_66 (_net0 I5_MM1_g) capacitor c=1.01724e-17
    ciD_65 (_net0 I5_I0_MM1_g) capacitor c=2.24906e-17
    ciD_64 (_net0 I5_I0_MM0_g) capacitor c=2.39354e-17
    ciD_63 (_net0 c_730_n) capacitor c=2.57155e-18
    ciD_62 (_net0 c_734_n) capacitor c=2.34999e-18
    ciD_61 (_net0 c_743_p) capacitor c=4.62578e-18
    ciD_60 (_net0 c_724_n) capacitor c=8.45243e-18
    ciD_59 (_net0 c_738_n) capacitor c=5.07995e-18
    ciD_58 (_net0 c_744_p) capacitor c=9.17787e-18
    ciD_57 (_net0 c_728_n) capacitor c=4.11734e-18
    ciW_EN_61 (_net0 I5_MM0_g) capacitor c=1.71867e-17
    ciW_EN_60 (_net0 I5_MM2_g) capacitor c=1.70088e-17
    ciW_EN_59 (_net0 c_680_p) capacitor c=1.51433e-17
    ciW_EN_58 (_net0 c_675_n) capacitor c=3.99584e-18
    ciW_EN_57 (_net0 c_694_p) capacitor c=4.24419e-18
    ciW_EN_56 (_net0 c_695_p) capacitor c=1.17359e-18
    ciW_EN_55 (_net0 c_676_n) capacitor c=6.36716e-18
    ciW_EN_54 (_net0 c_697_p) capacitor c=6.62663e-18
    ciW_EN_53 (_net0 W_EN) capacitor c=2.18252e-18
    ciW_EN_52 (_net0 c_678_n) capacitor c=1.16664e-18
    ciW_EN_51 (_net0 c_696_p) capacitor c=2.35072e-18
    ciBL_269 (_net0 c_526_p) capacitor c=5.09259e-18
    ciBL_268 (_net0 c_530_p) capacitor c=5.09259e-18
    ciBL_267 (_net0 c_534_p) capacitor c=5.09259e-18
    ciBL_266 (_net0 c_538_p) capacitor c=5.09259e-18
    ciBL_265 (_net0 I6_MM3_g) capacitor c=1.98629e-17
    ciBL_264 (_net0 I6_MM0_g) capacitor c=1.48222e-17
    ciBL_263 (_net0 c_452_p) capacitor c=3.46261e-18
    ciBL_262 (_net0 c_485_p) capacitor c=5.14463e-18
    ciBL_261 (_net0 c_465_p) capacitor c=4.37262e-18
    ciBL_260 (_net0 c_461_p) capacitor c=1.56566e-18
    ciBL_259 (_net0 c_503_p) capacitor c=8.73354e-19
    ciBL_258 (_net0 c_489_p) capacitor c=5.38394e-18
    ciBL_257 (_net0 c_446_p) capacitor c=2.47996e-17
    ciBL_256 (_net0 c_454_p) capacitor c=6.75627e-18
    ciBL_255 (_net0 c_574_p) capacitor c=3.12424e-18
    ciBL_254 (_net0 c_445_p) capacitor c=1.23522e-17
    ciBL_253 (_net0 BL_75) capacitor c=4.0033e-18
    ciBL_252 (_net0 c_499_p) capacitor c=5.2142e-18
    ciBL_251 (_net0 BL) capacitor c=4.14866e-17
    ciBL_250 (_net0 c_496_p) capacitor c=2.83285e-18
    ciBL_249 (_net0 c_493_p) capacitor c=1.89768e-18
    ciBL_248 (_net0 c_438_p) capacitor c=6.94563e-18
    ciBL_247 (_net0 I5_MM0_d) capacitor c=5.1886e-18
    ciBL_246 (_net0 c_440_p) capacitor c=2.92108e-17
    ciBL_245 (_net0 c_518_p) capacitor c=4.14446e-18
    ciBL_244 (_net0 c_528_p) capacitor c=3.23678e-17
    ciBL_243 (_net0 c_519_p) capacitor c=4.14446e-18
    ciBL_242 (_net0 c_529_p) capacitor c=5.45971e-18
    ciBL_241 (_net0 c_520_p) capacitor c=4.14446e-18
    ciBL_240 (_net0 c_533_p) capacitor c=4.94133e-17
    ciBL_239 (_net0 c_521_p) capacitor c=4.14446e-18
    ciBL_238 (_net0 c_537_p) capacitor c=5.45971e-18
    ciBL_237 (_net0 c_456_p) capacitor c=4.60654e-18
    ciBL_236 (_net0 c_497_p) capacitor c=7.17152e-18
    ciBL_235 (_net0 I6_MM1_d) capacitor c=5.09997e-18
    ciBL_234 (_net0 I4_MM2\@2_d) capacitor c=5.10547e-18
    ciXI0_net13_66 (_net0 I0_MM4_g) capacitor c=2.34653e-17
    ciXI0_net13_65 (_net0 I0_MM6_g) capacitor c=1.421e-17
    ciXI0_net13_64 (_net0 I0_MM5_d) capacitor c=6.52256e-18
    ciXI0_net13_63 (_net0 c_392_n) capacitor c=4.84908e-18
    ciXI0_net13_62 (_net0 I0_MM3_s) capacitor c=4.8965e-18
    ciXI0_net13_61 (_net0 c_385_n) capacitor c=1.3593e-17
    ciXI0_net13_60 (_net0 c_386_n) capacitor c=2.65589e-18
    ciXI0_net13_59 (_net0 c_387_n) capacitor c=1.85689e-18
    ciXI0_net13_58 (_net0 c_397_n) capacitor c=2.71676e-18
    ciXI0_net13_57 (_net0 I0_MM7_d) capacitor c=7.22262e-18
    ciXI0_net13_56 (_net0 c_399_n) capacitor c=2.89747e-18
    ciXI0_net13_55 (_net0 I0_net13) capacitor c=5.22871e-18
    ciXI0_net09_64 (_net0 I0_MM5_g) capacitor c=1.77831e-17
    ciXI0_net09_63 (_net0 I0_MM7_g) capacitor c=2.06305e-17
    ciXI0_net09_62 (_net0 c_332_n) capacitor c=2.65589e-18
    ciXI0_net09_61 (_net0 c_333_n) capacitor c=1.35346e-17
    ciXI0_net09_60 (_net0 I0_MM2_s) capacitor c=4.76051e-18
    ciXI0_net09_59 (_net0 c_335_n) capacitor c=3.12809e-18
    ciXI0_net09_58 (_net0 c_336_n) capacitor c=4.16362e-18
    ciXI0_net09_57 (_net0 c_337_n) capacitor c=6.28745e-19
    ciXI0_net09_56 (_net0 I0_MM4_d) capacitor c=6.55052e-18
    ciXI0_net09_55 (_net0 c_339_n) capacitor c=2.1992e-18
    ciXI0_net09_54 (_net0 c_331_n) capacitor c=9.5515e-18
    ciXI0_net09_53 (_net0 c_367_p) capacitor c=5.56536e-18
    ciXI1_net13_68 (_net0 I1_MM4_g) capacitor c=2.34653e-17
    ciXI1_net13_67 (_net0 I1_MM6_g) capacitor c=1.4191e-17
    ciXI1_net13_66 (_net0 I1_MM5_d) capacitor c=6.52256e-18
    ciXI1_net13_65 (_net0 c_281_n) capacitor c=4.88937e-18
    ciXI1_net13_64 (_net0 I1_MM3_s) capacitor c=4.8965e-18
    ciXI1_net13_63 (_net0 c_275_n) capacitor c=1.3593e-17
    ciXI1_net13_62 (_net0 c_276_n) capacitor c=2.65589e-18
    ciXI1_net13_61 (_net0 c_277_n) capacitor c=1.93918e-18
    ciXI1_net13_60 (_net0 c_286_n) capacitor c=2.71676e-18
    ciXI1_net13_59 (_net0 I1_MM7_d) capacitor c=7.21999e-18
    ciXI1_net13_58 (_net0 c_288_n) capacitor c=2.89747e-18
    ciXI1_net13_57 (_net0 I1_net13) capacitor c=5.21722e-18
    ciXI1_net09_64 (_net0 I1_MM5_g) capacitor c=1.77831e-17
    ciXI1_net09_63 (_net0 I1_MM7_g) capacitor c=2.06116e-17
    ciXI1_net09_62 (_net0 c_222_n) capacitor c=2.65589e-18
    ciXI1_net09_61 (_net0 c_223_n) capacitor c=1.35346e-17
    ciXI1_net09_60 (_net0 I1_MM2_s) capacitor c=4.76051e-18
    ciXI1_net09_59 (_net0 c_225_n) capacitor c=3.12809e-18
    ciXI1_net09_58 (_net0 c_226_n) capacitor c=4.16362e-18
    ciXI1_net09_57 (_net0 c_227_n) capacitor c=6.28745e-19
    ciXI1_net09_56 (_net0 I1_MM4_d) capacitor c=6.55052e-18
    ciXI1_net09_55 (_net0 c_229_n) capacitor c=2.1992e-18
    ciXI1_net09_54 (_net0 c_230_n) capacitor c=8.59085e-18
    ciXI1_net09_53 (_net0 c_256_p) capacitor c=5.56536e-18
    ciXI2_net13_69 (_net0 I2_MM4_g) capacitor c=2.34653e-17
    ciXI2_net13_68 (_net0 I2_MM6_g) capacitor c=1.4191e-17
    ciXI2_net13_67 (_net0 I2_MM5_d) capacitor c=6.51564e-18
    ciXI2_net13_66 (_net0 c_170_n) capacitor c=4.89301e-18
    ciXI2_net13_65 (_net0 I2_MM3_s) capacitor c=4.8965e-18
    ciXI2_net13_64 (_net0 c_164_n) capacitor c=1.3593e-17
    ciXI2_net13_63 (_net0 c_165_n) capacitor c=2.65589e-18
    ciXI2_net13_62 (_net0 c_166_n) capacitor c=1.93918e-18
    ciXI2_net13_61 (_net0 c_175_n) capacitor c=2.71676e-18
    ciXI2_net13_60 (_net0 I2_MM7_d) capacitor c=7.22784e-18
    ciXI2_net13_59 (_net0 c_177_n) capacitor c=2.89747e-18
    ciXI2_net13_58 (_net0 I2_net13) capacitor c=5.21722e-18
    ciXI2_net09_64 (_net0 I2_MM5_g) capacitor c=1.77831e-17
    ciXI2_net09_63 (_net0 I2_MM7_g) capacitor c=2.06116e-17
    ciXI2_net09_62 (_net0 c_111_n) capacitor c=2.65589e-18
    ciXI2_net09_61 (_net0 c_112_n) capacitor c=1.35346e-17
    ciXI2_net09_60 (_net0 I2_MM2_s) capacitor c=4.76051e-18
    ciXI2_net09_59 (_net0 c_114_n) capacitor c=3.12809e-18
    ciXI2_net09_58 (_net0 c_115_n) capacitor c=4.16362e-18
    ciXI2_net09_57 (_net0 c_116_n) capacitor c=6.28745e-19
    ciXI2_net09_56 (_net0 I2_MM4_d) capacitor c=6.55052e-18
    ciXI2_net09_55 (_net0 c_118_n) capacitor c=2.1992e-18
    ciXI2_net09_54 (_net0 c_119_n) capacitor c=8.59085e-18
    ciXI2_net09_53 (_net0 c_144_p) capacitor c=5.56536e-18
    ciXI3_net13_67 (_net0 I3_MM4_g) capacitor c=2.34653e-17
    ciXI3_net13_66 (_net0 I3_MM6_g) capacitor c=1.50238e-17
    ciXI3_net13_65 (_net0 I3_MM5_d) capacitor c=6.51806e-18
    ciXI3_net13_64 (_net0 c_61_n) capacitor c=4.81536e-18
    ciXI3_net13_63 (_net0 I3_MM3_s) capacitor c=4.8965e-18
    ciXI3_net13_62 (_net0 c_55_n) capacitor c=1.3593e-17
    ciXI3_net13_61 (_net0 c_56_n) capacitor c=2.65589e-18
    ciXI3_net13_60 (_net0 c_57_n) capacitor c=1.63017e-18
    ciXI3_net13_59 (_net0 c_66_n) capacitor c=2.71676e-18
    ciXI3_net13_58 (_net0 I3_MM7_d) capacitor c=7.22262e-18
    ciXI3_net13_57 (_net0 c_68_n) capacitor c=2.89747e-18
    ciXI3_net13_56 (_net0 I3_net13) capacitor c=5.2642e-18
    ciXI3_net09_63 (_net0 I3_MM5_g) capacitor c=1.77831e-17
    ciXI3_net09_62 (_net0 I3_MM7_g) capacitor c=2.14444e-17
    ciXI3_net09_61 (_net0 c_4_n) capacitor c=2.65589e-18
    ciXI3_net09_60 (_net0 c_5_n) capacitor c=1.35346e-17
    ciXI3_net09_59 (_net0 I3_MM2_s) capacitor c=4.76051e-18
    ciXI3_net09_58 (_net0 c_7_n) capacitor c=3.12809e-18
    ciXI3_net09_57 (_net0 c_8_n) capacitor c=4.16362e-18
    ciXI3_net09_56 (_net0 c_9_n) capacitor c=6.28745e-19
    ciXI3_net09_55 (_net0 I3_MM4_d) capacitor c=6.55052e-18
    ciXI3_net09_54 (_net0 c_11_n) capacitor c=2.1992e-18
    ciXI3_net09_53 (_net0 c_2_n) capacitor c=9.54389e-18
    ciXI3_net09_52 (_net0 c_36_p) capacitor c=5.56536e-18
    rWL1_33 (I1_MM3_g I1_MM2_g) resistor r=49.14
    rWL1_32 (c_1773_n I1_MM3_g) resistor r=24.96
    rWL1_31 (WL1_22 c_1776_n) resistor r=89.3538
    rWL1_30 (c_1773_n c_1776_n) resistor r=4.7687
    rWL1_29 (WL1_22 WL1) resistor r=0.0584615
    rWL2_33 (I2_MM3_g I2_MM2_g) resistor r=49.14
    rWL2_32 (c_1747_n I2_MM3_g) resistor r=24.96
    rWL2_31 (c_1754_n c_1750_n) resistor r=89.3538
    rWL2_30 (c_1747_n c_1750_n) resistor r=4.7687
    rWL2_29 (WL2 c_1754_n) resistor r=0.0438462
    rWL3_33 (I3_MM3_g I3_MM2_g) resistor r=49.14
    rWL3_32 (c_1721_n I3_MM3_g) resistor r=24.96
    rWL3_31 (c_1728_n c_1724_n) resistor r=89.3538
    rWL3_30 (c_1721_n c_1724_n) resistor r=4.7687
    rWL3_29 (WL3 c_1728_n) resistor r=0.0584615
    rWL0_34 (I0_MM3_g I0_MM2_g) resistor r=49.14
    rWL0_33 (c_1694_n I0_MM3_g) resistor r=24.96
    rWL0_32 (c_1701_n c_1697_n) resistor r=89.3538
    rWL0_31 (c_1694_n c_1697_n) resistor r=4.7687
    rWL0_30 (WL0 c_1701_n) resistor r=0.116923
    rPRE_B_54 (I4_MM0_g c_1665_n) resistor r=21.84
    rPRE_B_53 (c_1678_n c_1665_n) resistor r=3.30287
    rPRE_B_52 (I4_MM2\@2_g c_1667_n) resistor r=14.82
    rPRE_B_51 (c_1678_n c_1667_n) resistor r=3.30287
    rPRE_B_50 (PRE_B_8 c_1669_n) resistor r=21.84
    rPRE_B_49 (c_1680_n c_1669_n) resistor r=1.95
    rPRE_B_48 (c_1678_n PRE_B_8) resistor r=0.858359
    rPRE_B_47 (I4_MM1_g c_1674_n) resistor r=21.84
    rPRE_B_46 (c_1680_n c_1674_n) resistor r=1.95
    rPRE_B_45 (I4_MM2_g c_1670_n) resistor r=14.82
    rPRE_B_44 (c_1680_n c_1670_n) resistor r=1.95
    rPRE_B_43 (c_1682_n PRE_B_16) resistor r=24.96
    rPRE_B_42 (c_1680_n PRE_B_16) resistor r=1.95
    rPRE_B_41 (PRE_B_22 PRE_B) resistor r=0.19
    rPRE_B_40 (c_1690_n PRE_B_22) resistor r=89.3538
    rPRE_B_39 (c_1682_n c_1690_n) resistor r=4.7687
    rXI6_net25_93 (c_1603_n I6_MM6_d) resistor r=0.104316
    rXI6_net25_92 (c_1607_n I6_MM6_d) resistor r=0.108086
    rXI6_net25_91 (I6_net25 I6_MM2_g) resistor r=20.67
    rXI6_net25_90 (I6_net25_27 I6_MM7_d) resistor r=0.181231
    rXI6_net25_89 (c_1600_n I6_net25_15) resistor r=7.55615
    rXI6_net25_88 (I6_net25_18 I6_net25_15) resistor r=0.212415
    rXI6_net25_87 (c_1604_n c_1600_n) resistor r=0.21314
    rXI6_net25_86 (I6_net25_18 c_1629_n) resistor r=1.23852
    rXI6_net25_85 (I6_net25_27 c_1629_n) resistor r=0.0165691
    rXI6_net25_84 (c_1604_n c_1603_n) resistor r=1.1269
    rXI6_net25_83 (c_1608_n c_1607_n) resistor r=0.502143
    rXI6_net25_82 (c_1616_n c_1608_n) resistor r=0.214913
    rXI6_net25_81 (c_1616_n c_1609_n) resistor r=0.916471
    rXI6_net25_80 (I6_net25_31 c_1609_n) resistor r=0.146154
    rXI6_net25_79 (c_1642_n I6_net25_31) resistor r=89.3538
    rXI6_net25_78 (I6_net25 c_1642_n) resistor r=4.7687
    rvdd_216 (I0_MM6_b I0_MM7_b) resistor r=0.01
    rvdd_215 (I0_MM6_b I4_MM0_b) resistor r=0.01
    rvdd_214 (I0_MM6_b I4_MM2\@2_b) resistor r=0.01
    rvdd_213 (I0_MM6_b I4_MM1_b) resistor r=0.01
    rvdd_212 (I0_MM6_b I4_MM2_b) resistor r=0.01
    rvdd_211 (I2_MM6_b I2_MM7_b) resistor r=0.01
    rvdd_210 (I2_MM6_b I1_MM6_b) resistor r=0.01
    rvdd_209 (I2_MM6_b I1_MM7_b) resistor r=0.01
    rvdd_208 (I3_MM6_b I3_MM7_b) resistor r=0.01
    rvdd_207 (I3_MM6_b I5_I0_MM0_b) resistor r=0.01
    rvdd_206 (I6_MM1_b I6_MM6_b) resistor r=0.01
    rvdd_205 (I6_MM1_b I6_MM0_b) resistor r=0.01
    rvdd_204 (I6_MM1_b I6_MM2_b) resistor r=0.01
    rvdd_203 (I6_MM6_s I6_MM2_s) resistor r=0.01
    rvdd_202 (I4_MM0_s I4_MM1_s) resistor r=0.01
    rvdd_201 (I0_MM6_s I0_MM7_s) resistor r=0.01
    rvdd_200 (I1_MM6_s I1_MM7_s) resistor r=0.01
    rvdd_199 (I2_MM6_s I2_MM7_s) resistor r=0.01
    rvdd_198 (I3_MM6_s I3_MM7_s) resistor r=0.01
    rvdd_197 (I5_I0_MM0_s vdd_54) resistor r=0.789231
    rvdd_196 (vdd_88 vdd_54) resistor r=0.151673
    rvdd_195 (I3_MM6_s vdd_57) resistor r=0.745385
    rvdd_194 (I3_MM6_b vdd_57) resistor r=0.151673
    rvdd_193 (I2_MM6_s vdd_60) resistor r=0.745385
    rvdd_192 (I2_MM6_b vdd_60) resistor r=0.156557
    rvdd_191 (I1_MM6_s vdd_63) resistor r=0.745385
    rvdd_190 (I2_MM6_b vdd_63) resistor r=0.156557
    rvdd_189 (I0_MM6_s vdd_66) resistor r=0.833077
    rvdd_188 (I0_MM6_b vdd_66) resistor r=0.144492
    rvdd_187 (I4_MM0_s vdd_69) resistor r=0.686923
    rvdd_186 (vdd_97 vdd_69) resistor r=0.144492
    rvdd_185 (I6_MM6_s vdd_73) resistor r=0.774615
    rvdd_184 (c_1462_n vdd_73) resistor r=0.25156
    rvdd_183 (I6_MM1_b c_1462_n) resistor r=0.373214
    rvdd_182 (c_1468_n I6_MM1_b) resistor r=2.375
    rvdd_181 (c_1464_n c_1501_n) resistor r=3.94615
    rvdd_180 (vdd_107 c_1501_n) resistor r=0.117309
    rvdd_179 (I2_MM6_b c_1464_n) resistor r=0.388844
    rvdd_178 (c_1465_n c_1503_n) resistor r=3.57907
    rvdd_177 (vdd_112 c_1503_n) resistor r=0.107552
    rvdd_176 (vdd_97 c_1465_n) resistor r=0.377647
    rvdd_175 (c_1467_n c_1508_n) resistor r=3.65524
    rvdd_174 (vdd_104 c_1508_n) resistor r=0.10994
    rvdd_173 (I3_MM6_b c_1467_n) resistor r=0.392187
    rvdd_172 (I3_MM6_b vdd_88) resistor r=0.2673
    rvdd_171 (vdd_97 I0_MM6_b) resistor r=0.0150198
    rvdd_170 (vdd_102 c_1528_n) resistor r=6.78571
    rvdd_169 (c_1533_n c_1528_n) resistor r=102.4
    rvdd_168 (c_1468_n c_1533_n) resistor r=0.0866667
    rvdd_167 (vdd_105 vdd_102) resistor r=9.49107
    rvdd_166 (vdd_104 vdd_102) resistor r=102.4
    rvdd_165 (vdd vdd_105) resistor r=8.57143
    rvdd_164 (vdd_107 vdd_105) resistor r=102.4
    rvdd_163 (vdd_110 vdd) resistor r=0.910714
    rvdd_162 (vdd_112 vdd_110) resistor r=102.4
    rgnd_332 (I6_MM7_b I6_MM4_b) resistor r=0.01
    rgnd_331 (I6_MM7_b I6_MM5_b) resistor r=0.01
    rgnd_330 (I6_MM7_b I6_MM3_b) resistor r=0.01
    rgnd_329 (I1_MM2_b I1_MM3_b) resistor r=0.01
    rgnd_328 (I1_MM2_b I1_MM4_b) resistor r=0.01
    rgnd_327 (I1_MM2_b I1_MM5_b) resistor r=0.01
    rgnd_326 (I1_MM2_b I0_MM2_b) resistor r=0.01
    rgnd_325 (I1_MM2_b I0_MM3_b) resistor r=0.01
    rgnd_324 (I1_MM2_b I0_MM4_b) resistor r=0.01
    rgnd_323 (I1_MM2_b I0_MM5_b) resistor r=0.01
    rgnd_322 (I3_MM2_b I3_MM3_b) resistor r=0.01
    rgnd_321 (I3_MM2_b I3_MM4_b) resistor r=0.01
    rgnd_320 (I3_MM2_b I3_MM5_b) resistor r=0.01
    rgnd_319 (I3_MM2_b I2_MM2_b) resistor r=0.01
    rgnd_318 (I3_MM2_b I2_MM3_b) resistor r=0.01
    rgnd_317 (I3_MM2_b I2_MM4_b) resistor r=0.01
    rgnd_316 (I3_MM2_b I2_MM5_b) resistor r=0.01
    rgnd_315 (I5_MM0_b I5_MM1_b) resistor r=0.01
    rgnd_314 (I5_MM0_b I5_I0_MM1_b) resistor r=0.01
    rgnd_313 (I5_MM0_b I5_MM3_b) resistor r=0.01
    rgnd_312 (I5_MM0_b I5_MM2_b) resistor r=0.01
    rgnd_311 (I6_MM7_s I6_MM5_s) resistor r=0.01
    rgnd_310 (I5_MM1_s I5_MM3_s) resistor r=0.01
    rgnd_309 (I0_MM4_s I0_MM5_s) resistor r=0.01
    rgnd_308 (I1_MM4_s I1_MM5_s) resistor r=0.01
    rgnd_307 (I2_MM4_s I2_MM5_s) resistor r=0.01
    rgnd_306 (I3_MM4_s I3_MM5_s) resistor r=0.01
    rgnd_305 (I5_I0_MM1_s gnd_82) resistor r=0.789231
    rgnd_304 (I5_MM0_b gnd_82) resistor r=0.122938
    rgnd_303 (I3_MM4_s gnd_85) resistor r=2.73308
    rgnd_302 (c_1241_n gnd_85) resistor r=0.0950001
    rgnd_301 (I2_MM4_s gnd_88) resistor r=2.73308
    rgnd_300 (c_1241_n gnd_88) resistor r=0.0950001
    rgnd_299 (I1_MM4_s gnd_91) resistor r=2.73308
    rgnd_298 (c_1246_n gnd_91) resistor r=0.0950001
    rgnd_297 (I0_MM4_s gnd_94) resistor r=2.73308
    rgnd_296 (c_1246_n gnd_94) resistor r=0.0950001
    rgnd_295 (gnd_130 I5_MM1_s) resistor r=0.803846
    rgnd_294 (gnd_101 c_1312_n) resistor r=0.38
    rgnd_293 (I3_MM2_b c_1312_n) resistor r=0.0281481
    rgnd_292 (c_1241_n gnd_101) resistor r=0.0950001
    rgnd_291 (gnd_103 c_1315_n) resistor r=0.38
    rgnd_290 (I1_MM2_b c_1315_n) resistor r=0.0281481
    rgnd_289 (c_1246_n gnd_103) resistor r=0.0950001
    rgnd_288 (c_1238_n c_1252_n) resistor r=0.2584
    rgnd_287 (c_1285_n c_1252_n) resistor r=0.201755
    rgnd_286 (gnd_130 c_1238_n) resistor r=0.109778
    rgnd_285 (I6_MM7_s gnd_106) resistor r=1.19846
    rgnd_284 (c_1275_n gnd_106) resistor r=0.216227
    rgnd_283 (c_1275_n c_1240_n) resistor r=0.518182
    rgnd_282 (I6_MM7_b c_1240_n) resistor r=0.145524
    rgnd_281 (c_1254_n c_1285_n) resistor r=2.55941
    rgnd_280 (c_1341_n c_1321_n) resistor r=1.89073
    rgnd_279 (I3_MM2_b c_1321_n) resistor r=0.184789
    rgnd_278 (c_1343_n c_1322_n) resistor r=1.49077
    rgnd_277 (I1_MM2_b c_1322_n) resistor r=0.161852
    rgnd_276 (c_1335_n c_1276_n) resistor r=1.995
    rgnd_275 (I6_MM7_b c_1276_n) resistor r=0.209307
    rgnd_274 (gnd_130 I5_MM0_b) resistor r=0.337778
    rgnd_273 (gnd_145 c_1326_n) resistor r=7.04464
    rgnd_272 (c_1293_n c_1326_n) resistor r=102.4
    rgnd_271 (c_1335_n c_1293_n) resistor r=0.0292308
    rgnd_270 (gnd_148 gnd_145) resistor r=7.82143
    rgnd_269 (c_1357_p gnd_145) resistor r=102.4
    rgnd_268 (c_1254_n c_1357_p) resistor r=0.0292308
    rgnd_267 (gnd_151 gnd_148) resistor r=9.48214
    rgnd_266 (c_1346_p gnd_148) resistor r=102.4
    rgnd_265 (c_1341_n c_1346_p) resistor r=0.114418
    rgnd_264 (gnd gnd_151) resistor r=0.5
    rgnd_263 (c_1347_p gnd_151) resistor r=102.4
    rgnd_262 (c_1343_n c_1347_p) resistor r=0.0900928
    rBLB_349 (c_997_n BLB_11) resistor r=102.4
    rBLB_348 (I3_MM3_d BLB_11) resistor r=0.00562963
    rBLB_347 (c_998_n BLB_20) resistor r=102.4
    rBLB_346 (I2_MM3_d BLB_20) resistor r=0.00562963
    rBLB_345 (c_999_n BLB_29) resistor r=102.4
    rBLB_344 (I1_MM3_d BLB_29) resistor r=0.00562963
    rBLB_343 (c_1000_n BLB_38) resistor r=102.4
    rBLB_342 (I0_MM3_d BLB_38) resistor r=0.00562963
    rBLB_341 (BLB_129 I6_MM4_g) resistor r=24.18
    rBLB_340 (BLB_130 I6_MM1_g) resistor r=40.95
    rBLB_339 (I4_MM2\@2_s BLB_67) resistor r=0.800714
    rBLB_338 (c_978_n BLB_67) resistor r=0.212696
    rBLB_337 (c_978_n c_974_n) resistor r=1.81231
    rBLB_336 (c_1127_p c_974_n) resistor r=0.0418175
    rBLB_335 (BLB_74 c_980_n) resistor r=1.19846
    rBLB_334 (c_1070_p c_980_n) resistor r=0.0418175
    rBLB_333 (c_992_n BLB_74) resistor r=0.0223169
    rBLB_332 (I4_MM2_s BLB_75) resistor r=0.862308
    rBLB_331 (c_1127_p BLB_75) resistor r=0.160909
    rBLB_330 (I6_MM3_d BLB_79) resistor r=0.774615
    rBLB_329 (c_1070_p BLB_79) resistor r=0.160909
    rBLB_328 (c_988_n BLB_82) resistor r=1.54923
    rBLB_327 (c_1070_p BLB_82) resistor r=0.160909
    rBLB_326 (c_1003_n c_988_n) resistor r=0.189847
    rBLB_325 (BLB_87 c_992_n) resistor r=0.204615
    rBLB_324 (c_995_n BLB_87) resistor r=89.3538
    rBLB_323 (BLB_129 c_995_n) resistor r=4.7687
    rBLB_322 (BLB_130 c_995_n) resistor r=4.7687
    rBLB_321 (c_1127_p BLB_91) resistor r=0.160909
    rBLB_320 (I4_MM1_d BLB_91) resistor r=0.774615
    rBLB_319 (c_1012_n BLB_94) resistor r=4.77679
    rBLB_318 (c_1018_n BLB_94) resistor r=0.140906
    rBLB_317 (c_997_n c_1012_n) resistor r=0.122544
    rBLB_316 (c_1042_p BLB_96) resistor r=0.946429
    rBLB_315 (c_997_n BLB_96) resistor r=0.122544
    rBLB_314 (c_998_n c_1042_p) resistor r=0.122544
    rBLB_313 (c_1046_p BLB_98) resistor r=8.01786
    rBLB_312 (c_998_n BLB_98) resistor r=0.122544
    rBLB_311 (c_999_n c_1046_p) resistor r=0.122544
    rBLB_310 (c_1050_p BLB_100) resistor r=0.946429
    rBLB_309 (c_999_n BLB_100) resistor r=0.122544
    rBLB_308 (c_1000_n c_1050_p) resistor r=0.122544
    rBLB_307 (c_1054_p BLB_102) resistor r=4.73214
    rBLB_306 (c_1000_n BLB_102) resistor r=0.122544
    rBLB_305 (BLB c_1054_p) resistor r=0.00892857
    rBLB_304 (I4_MM1_d c_1054_p) resistor r=102.4
    rBLB_303 (c_1018_n c_1107_p) resistor r=0.568182
    rBLB_302 (c_1004_n c_1107_p) resistor r=0.140906
    rBLB_301 (c_1007_n BLB_111) resistor r=3.35714
    rBLB_300 (BLB_122 BLB_111) resistor r=0.0472979
    rBLB_299 (c_1004_n BLB_113) resistor r=2.52679
    rBLB_298 (c_1005_n BLB_113) resistor r=0.18272
    rBLB_297 (BLB_122 c_1001_n) resistor r=0.375683
    rBLB_296 (c_1003_n c_1001_n) resistor r=102.4
    rBLB_295 (I6_MM0_d c_1003_n) resistor r=0.134911
    rBLB_294 (c_1007_n c_1005_n) resistor r=0.18272
    rBLB_293 (I5_MM2_d c_1005_n) resistor r=102.4
    rXI6_net15_57 (I6_net15 I6_MM0_s) resistor r=0.01
    rXI6_net15_56 (I6_net15 I6_MM1_s) resistor r=0.01
    rXI6_net15_55 (I6_net15_17 I6_MM2_d) resistor r=102.4
    rXI6_net15_54 (c_933_n c_922_n) resistor r=0.991667
    rXI6_net15_53 (I6_net15_11 c_922_n) resistor r=0.15
    rXI6_net15_52 (c_934_n c_933_n) resistor r=0.139898
    rXI6_net15_51 (c_934_n c_944_p) resistor r=0.401786
    rXI6_net15_50 (c_931_n c_944_p) resistor r=0.0146822
    rXI6_net15_49 (I6_net15_13 I6_net15_11) resistor r=102.4
    rXI6_net15_48 (I6_net15 I6_net15_13) resistor r=0.00140741
    rXI6_net15_47 (I6_net15_17 c_931_n) resistor r=0.116071
    rXI6_net17_41 (I6_net17 I6_MM5_d) resistor r=0.01
    rXI6_net17_40 (I6_MM4_s I6_MM3_s) resistor r=0.01
    rXI6_net17_39 (c_899_n I6_MM4_s) resistor r=0.175385
    rXI6_net17_38 (I6_net17_8 c_896_n) resistor r=0.410714
    rXI6_net17_37 (I6_net17_9 c_896_n) resistor r=0.139682
    rXI6_net17_36 (I6_net17_18 I6_net17_8) resistor r=0.0146822
    rXI6_net17_35 (c_897_n I6_net17_9) resistor r=1.53571
    rXI6_net17_34 (c_904_n c_897_n) resistor r=102.4
    rXI6_net17_33 (I6_net17 c_904_n) resistor r=0.0730769
    rXI6_net17_32 (c_899_n c_898_n) resistor r=102.4
    rXI6_net17_31 (I6_net17_18 c_898_n) resistor r=0.116071
    rXI5_net21_80 (I5_MM3_g I5_net21_9) resistor r=22.62
    rXI5_net21_79 (c_851_n I5_net21_9) resistor r=4.7687
    rXI5_net21_78 (I5_net21_22 I5_I0_MM1_d) resistor r=0.964615
    rXI5_net21_77 (c_860_n I5_I0_MM0_d) resistor r=1.08154
    rXI5_net21_76 (I5_net21_22 c_857_n) resistor r=0.192522
    rXI5_net21_75 (I5_net21_30 c_857_n) resistor r=0.176429
    rXI5_net21_74 (c_860_n I5_net21_23) resistor r=0.192522
    rXI5_net21_73 (I5_net21_30 I5_net21_23) resistor r=0.176429
    rXI5_net21_72 (I5_net21_36 c_845_n) resistor r=2.5625
    rXI5_net21_71 (c_863_n c_845_n) resistor r=0.126465
    rXI5_net21_70 (c_866_n c_863_n) resistor r=0.1
    rXI5_net21_69 (I5_net21_30 c_866_n) resistor r=102.4
    rXI5_net21_68 (I5_net21 c_847_n) resistor r=102.4
    rXI5_net21_67 (I5_net21_36 c_847_n) resistor r=0.195441
    rXI5_net21_66 (I5_net21 c_851_n) resistor r=89.3538
    rSE_96 (I6_MM7_g SE_1) resistor r=15.6
    rSE_95 (SE_35 SE_1) resistor r=2.56494
    rSE_94 (I6_MM6_g SE_5) resistor r=32.76
    rSE_93 (SE_31 SE_5) resistor r=1.62364
    rSE_92 (c_781_n c_780_n) resistor r=21.84
    rSE_91 (SE_11 c_780_n) resistor r=4.35808
    rSE_90 (SE_35 c_781_n) resistor r=3.64926
    rSE_89 (I6_MM5_g SE_11) resistor r=15.6
    rSE_88 (c_782_n SE_15) resistor r=5.18846
    rSE_87 (c_829_p SE_15) resistor r=0.212415
    rSE_86 (c_835_p c_782_n) resistor r=0.212696
    rSE_85 (c_829_p c_787_n) resistor r=0.478519
    rSE_84 (SE_40 c_787_n) resistor r=0.0165691
    rSE_83 (c_835_p c_789_n) resistor r=0.407143
    rSE_82 (SE_24 c_789_n) resistor r=0.0289537
    rSE_81 (SE_24 c_790_n) resistor r=0.0917241
    rSE_80 (c_794_n c_790_n) resistor r=89.3538
    rSE_79 (SE_31 c_794_n) resistor r=12.3309
    rSE_78 (c_796_n SE_33) resistor r=89.3538
    rSE_77 (SE_35 SE_33) resistor r=8.69143
    rSE_76 (SE c_796_n) resistor r=0.19
    rSE_75 (SE_40 SE) resistor r=0.00584615
    rD_81 (D_27 I5_MM1_g) resistor r=22.62
    rD_80 (I5_I0_MM1_g D_5) resistor r=29.25
    rD_79 (c_744_p D_5) resistor r=1.98872
    rD_78 (I5_I0_MM0_g D_9) resistor r=28.86
    rD_77 (c_744_p D_9) resistor r=1.98872
    rD_76 (c_724_n c_730_n) resistor r=2.5625
    rD_75 (D_15 c_730_n) resistor r=0.239362
    rD_74 (c_734_n D_15) resistor r=102.4
    rD_73 (c_738_n c_734_n) resistor r=89.3538
    rD_72 (c_728_n c_743_p) resistor r=102.4
    rD_71 (c_724_n c_743_p) resistor r=0.193357
    rD_70 (D_27 c_738_n) resistor r=4.7687
    rD_69 (c_728_n D_29) resistor r=89.3538
    rD_68 (c_744_p D_29) resistor r=7.02
    rD_67 (c_728_n D) resistor r=0.0217557
    rW_EN_76 (W_EN_27 I5_MM0_g) resistor r=22.62
    rW_EN_75 (W_EN_32 I5_MM2_g) resistor r=22.62
    rW_EN_74 (W_EN_15 c_680_p) resistor r=1.59091
    rW_EN_73 (c_694_p c_680_p) resistor r=0.110714
    rW_EN_72 (W_EN_47 c_675_n) resistor r=88.2939
    rW_EN_71 (W_EN_15 c_675_n) resistor r=0.101786
    rW_EN_70 (c_695_p c_694_p) resistor r=88.2939
    rW_EN_69 (c_696_p c_695_p) resistor r=102.4
    rW_EN_68 (W_EN_36 c_676_n) resistor r=89.3538
    rW_EN_67 (W_EN_27 c_676_n) resistor r=4.7687
    rW_EN_66 (c_696_p c_697_p) resistor r=89.3538
    rW_EN_65 (W_EN_32 c_697_p) resistor r=4.7687
    rW_EN_64 (W_EN_36 W_EN) resistor r=0.0876923
    rW_EN_63 (c_678_n W_EN_36) resistor r=102.4
    rW_EN_62 (W_EN_47 c_678_n) resistor r=0.00892857
    rBL_328 (I4_MM2\@2_d I4_MM2_d) resistor r=0.01
    rBL_327 (c_518_p c_526_p) resistor r=102.4
    rBL_326 (I3_MM2_d c_526_p) resistor r=0.00140741
    rBL_325 (c_519_p c_530_p) resistor r=102.4
    rBL_324 (I2_MM2_d c_530_p) resistor r=0.00140741
    rBL_323 (c_520_p c_534_p) resistor r=102.4
    rBL_322 (I1_MM2_d c_534_p) resistor r=0.00140741
    rBL_321 (c_521_p c_538_p) resistor r=102.4
    rBL_320 (I0_MM2_d c_538_p) resistor r=0.00140741
    rBL_319 (BL_122 I6_MM3_g) resistor r=44.46
    rBL_318 (BL_123 I6_MM0_g) resistor r=20.67
    rBL_317 (c_485_p c_452_p) resistor r=1.54923
    rBL_316 (I6_MM4_d c_452_p) resistor r=0.322765
    rBL_315 (c_461_p c_485_p) resistor r=0.160909
    rBL_314 (BL_57 c_465_p) resistor r=1.19846
    rBL_313 (BL_66 c_465_p) resistor r=0.0223169
    rBL_312 (c_461_p BL_57) resistor r=0.0418175
    rBL_311 (c_461_p BL_60) resistor r=0.160909
    rBL_310 (I6_MM1_d BL_60) resistor r=0.423846
    rBL_309 (BL_66 c_503_p) resistor r=0.204615
    rBL_308 (c_489_p c_503_p) resistor r=89.3538
    rBL_307 (BL_122 c_489_p) resistor r=4.7687
    rBL_306 (BL_123 c_489_p) resistor r=4.7687
    rBL_305 (c_440_p BL_68) resistor r=3.35714
    rBL_304 (c_574_p BL_68) resistor r=0.139682
    rBL_303 (c_446_p BL_70) resistor r=2.52679
    rBL_302 (c_438_p BL_70) resistor r=0.18272
    rBL_301 (BL_75 c_446_p) resistor r=0.140906
    rBL_300 (c_574_p c_454_p) resistor r=0.955357
    rBL_299 (BL_113 c_454_p) resistor r=0.0146822
    rBL_298 (BL_75 c_445_p) resistor r=0.530303
    rBL_297 (BL_76 c_445_p) resistor r=0.140906
    rBL_296 (c_528_p BL_76) resistor r=4.78571
    rBL_295 (c_529_p BL_78) resistor r=0.928571
    rBL_294 (c_518_p BL_78) resistor r=0.122544
    rBL_293 (c_533_p BL_80) resistor r=8.03571
    rBL_292 (c_519_p BL_80) resistor r=0.122544
    rBL_291 (c_537_p BL_82) resistor r=0.928571
    rBL_290 (c_520_p BL_82) resistor r=0.122544
    rBL_289 (BL BL_84) resistor r=4.74107
    rBL_288 (c_521_p BL_84) resistor r=0.122544
    rBL_287 (BL BL_85) resistor r=1.16071
    rBL_286 (c_493_p BL_85) resistor r=0.139738
    rBL_285 (BL c_499_p) resistor r=102.4
    rBL_284 (I4_MM0_d c_499_p) resistor r=0.00703704
    rBL_283 (c_493_p c_496_p) resistor r=0.387931
    rBL_282 (BL_119 c_496_p) resistor r=0.0111667
    rBL_281 (c_440_p c_438_p) resistor r=0.18272
    rBL_280 (I5_MM0_d c_438_p) resistor r=102.4
    rBL_279 (c_528_p c_518_p) resistor r=0.122544
    rBL_278 (c_529_p c_519_p) resistor r=0.122544
    rBL_277 (c_533_p c_520_p) resistor r=0.122544
    rBL_276 (c_537_p c_521_p) resistor r=0.122544
    rBL_275 (BL_113 c_456_p) resistor r=0.116071
    rBL_274 (BL_111 c_456_p) resistor r=102.4
    rBL_273 (I6_MM1_d BL_111) resistor r=0.175385
    rBL_272 (BL_119 c_497_p) resistor r=0.0839286
    rBL_271 (BL_117 c_497_p) resistor r=102.4
    rBL_270 (I4_MM2\@2_d BL_117) resistor r=0.00703704
    rXI0_net13_85 (I0_MM4_g I0_net13_4) resistor r=45.24
    rXI0_net13_84 (I0_net13 I0_net13_4) resistor r=1.98872
    rXI0_net13_83 (I0_MM6_g I0_net13_8) resistor r=24.18
    rXI0_net13_82 (I0_net13 I0_net13_8) resistor r=1.98872
    rXI0_net13_81 (c_397_n I0_MM5_d) resistor r=0.244533
    rXI0_net13_80 (I0_net13_32 I0_MM5_d) resistor r=0.297556
    rXI0_net13_79 (I0_net13_15 c_392_n) resistor r=1.46154
    rXI0_net13_78 (c_399_n c_392_n) resistor r=0.0418175
    rXI0_net13_77 (I0_net13_26 I0_net13_15) resistor r=0.0223169
    rXI0_net13_76 (c_397_n I0_MM3_s) resistor r=0.584615
    rXI0_net13_75 (I0_net13_32 c_385_n) resistor r=1.92923
    rXI0_net13_74 (c_399_n c_385_n) resistor r=0.160909
    rXI0_net13_73 (c_386_n I0_net13_20) resistor r=0.38
    rXI0_net13_72 (c_399_n I0_net13_20) resistor r=0.160909
    rXI0_net13_71 (I0_net13_35 c_386_n) resistor r=0.137809
    rXI0_net13_70 (I0_net13_26 c_387_n) resistor r=0.204615
    rXI0_net13_69 (I0_net13_24 c_387_n) resistor r=89.3538
    rXI0_net13_68 (I0_net13 I0_net13_24) resistor r=2.34
    rXI0_net13_67 (I0_net13_35 I0_MM7_d) resistor r=0.132377
    rXI0_net09_83 (I0_MM5_g I0_net09_4) resistor r=24.96
    rXI0_net09_82 (c_367_p I0_net09_4) resistor r=4.7687
    rXI0_net09_81 (I0_net09 I0_MM7_g) resistor r=44.46
    rXI0_net09_80 (c_332_n I0_net09_14) resistor r=0.38
    rXI0_net09_79 (I0_net09_27 I0_net09_14) resistor r=0.110354
    rXI0_net09_78 (c_339_n c_332_n) resistor r=0.160909
    rXI0_net09_77 (c_333_n I0_net09_16) resistor r=1.92923
    rXI0_net09_76 (c_339_n I0_net09_16) resistor r=0.160909
    rXI0_net09_75 (c_331_n c_333_n) resistor r=0.154478
    rXI0_net09_74 (c_335_n I0_MM2_s) resistor r=0.672308
    rXI0_net09_73 (I0_MM4_d c_335_n) resistor r=0.110354
    rXI0_net09_72 (I0_net09_21 c_336_n) resistor r=1.54923
    rXI0_net09_71 (I0_net09_22 c_336_n) resistor r=0.212317
    rXI0_net09_70 (c_339_n I0_net09_21) resistor r=0.0418175
    rXI0_net09_69 (c_337_n I0_net09_22) resistor r=0.394615
    rXI0_net09_68 (c_367_p c_337_n) resistor r=89.3538
    rXI0_net09_67 (I0_MM4_d I0_net09_27) resistor r=0.217143
    rXI0_net09_66 (I0_MM6_d c_331_n) resistor r=0.170787
    rXI0_net09_65 (I0_net09 c_367_p) resistor r=4.7687
    rXI1_net13_87 (I1_MM4_g I1_net13_4) resistor r=45.24
    rXI1_net13_86 (I1_net13 I1_net13_4) resistor r=1.98872
    rXI1_net13_85 (I1_MM6_g I1_net13_8) resistor r=24.18
    rXI1_net13_84 (I1_net13 I1_net13_8) resistor r=1.98872
    rXI1_net13_83 (c_286_n I1_MM5_d) resistor r=0.244533
    rXI1_net13_82 (I1_net13_32 I1_MM5_d) resistor r=0.297556
    rXI1_net13_81 (I1_net13_15 c_281_n) resistor r=1.46154
    rXI1_net13_80 (c_288_n c_281_n) resistor r=0.0418175
    rXI1_net13_79 (I1_net13_26 I1_net13_15) resistor r=0.0223169
    rXI1_net13_78 (c_286_n I1_MM3_s) resistor r=0.584615
    rXI1_net13_77 (I1_net13_32 c_275_n) resistor r=1.92923
    rXI1_net13_76 (c_288_n c_275_n) resistor r=0.160909
    rXI1_net13_75 (c_276_n I1_net13_20) resistor r=0.38
    rXI1_net13_74 (c_288_n I1_net13_20) resistor r=0.160909
    rXI1_net13_73 (I1_net13_35 c_276_n) resistor r=0.137809
    rXI1_net13_72 (I1_net13_26 c_277_n) resistor r=0.204615
    rXI1_net13_71 (I1_net13_24 c_277_n) resistor r=89.3538
    rXI1_net13_70 (I1_net13 I1_net13_24) resistor r=2.34
    rXI1_net13_69 (I1_net13_35 I1_MM7_d) resistor r=0.132377
    rXI1_net09_83 (I1_MM5_g I1_net09_4) resistor r=24.96
    rXI1_net09_82 (c_256_p I1_net09_4) resistor r=4.7687
    rXI1_net09_81 (I1_net09 I1_MM7_g) resistor r=44.46
    rXI1_net09_80 (c_222_n I1_net09_14) resistor r=0.38
    rXI1_net09_79 (I1_net09_27 I1_net09_14) resistor r=0.110354
    rXI1_net09_78 (c_229_n c_222_n) resistor r=0.160909
    rXI1_net09_77 (c_223_n I1_net09_16) resistor r=1.92923
    rXI1_net09_76 (c_229_n I1_net09_16) resistor r=0.160909
    rXI1_net09_75 (c_230_n c_223_n) resistor r=0.154478
    rXI1_net09_74 (c_225_n I1_MM2_s) resistor r=0.672308
    rXI1_net09_73 (I1_MM4_d c_225_n) resistor r=0.110354
    rXI1_net09_72 (I1_net09_21 c_226_n) resistor r=1.54923
    rXI1_net09_71 (I1_net09_22 c_226_n) resistor r=0.212317
    rXI1_net09_70 (c_229_n I1_net09_21) resistor r=0.0418175
    rXI1_net09_69 (c_227_n I1_net09_22) resistor r=0.394615
    rXI1_net09_68 (c_256_p c_227_n) resistor r=89.3538
    rXI1_net09_67 (I1_MM4_d I1_net09_27) resistor r=0.217143
    rXI1_net09_66 (I1_MM6_d c_230_n) resistor r=0.170787
    rXI1_net09_65 (I1_net09 c_256_p) resistor r=4.7687
    rXI2_net13_88 (I2_MM4_g I2_net13_4) resistor r=45.24
    rXI2_net13_87 (I2_net13 I2_net13_4) resistor r=1.98872
    rXI2_net13_86 (I2_MM6_g I2_net13_8) resistor r=24.18
    rXI2_net13_85 (I2_net13 I2_net13_8) resistor r=1.98872
    rXI2_net13_84 (c_175_n I2_MM5_d) resistor r=0.244533
    rXI2_net13_83 (I2_net13_32 I2_MM5_d) resistor r=0.297556
    rXI2_net13_82 (I2_net13_15 c_170_n) resistor r=1.46154
    rXI2_net13_81 (c_177_n c_170_n) resistor r=0.0418175
    rXI2_net13_80 (I2_net13_26 I2_net13_15) resistor r=0.0223169
    rXI2_net13_79 (c_175_n I2_MM3_s) resistor r=0.584615
    rXI2_net13_78 (I2_net13_32 c_164_n) resistor r=1.92923
    rXI2_net13_77 (c_177_n c_164_n) resistor r=0.160909
    rXI2_net13_76 (c_165_n I2_net13_20) resistor r=0.38
    rXI2_net13_75 (c_177_n I2_net13_20) resistor r=0.160909
    rXI2_net13_74 (I2_net13_35 c_165_n) resistor r=0.137809
    rXI2_net13_73 (I2_net13_26 c_166_n) resistor r=0.204615
    rXI2_net13_72 (I2_net13_24 c_166_n) resistor r=89.3538
    rXI2_net13_71 (I2_net13 I2_net13_24) resistor r=2.34
    rXI2_net13_70 (I2_net13_35 I2_MM7_d) resistor r=0.132377
    rXI2_net09_83 (I2_MM5_g I2_net09_4) resistor r=24.96
    rXI2_net09_82 (c_144_p I2_net09_4) resistor r=4.7687
    rXI2_net09_81 (I2_net09 I2_MM7_g) resistor r=44.46
    rXI2_net09_80 (c_111_n I2_net09_14) resistor r=0.38
    rXI2_net09_79 (I2_net09_27 I2_net09_14) resistor r=0.110354
    rXI2_net09_78 (c_118_n c_111_n) resistor r=0.160909
    rXI2_net09_77 (c_112_n I2_net09_16) resistor r=1.92923
    rXI2_net09_76 (c_118_n I2_net09_16) resistor r=0.160909
    rXI2_net09_75 (c_119_n c_112_n) resistor r=0.154478
    rXI2_net09_74 (c_114_n I2_MM2_s) resistor r=0.672308
    rXI2_net09_73 (I2_MM4_d c_114_n) resistor r=0.110354
    rXI2_net09_72 (I2_net09_21 c_115_n) resistor r=1.54923
    rXI2_net09_71 (I2_net09_22 c_115_n) resistor r=0.212317
    rXI2_net09_70 (c_118_n I2_net09_21) resistor r=0.0418175
    rXI2_net09_69 (c_116_n I2_net09_22) resistor r=0.394615
    rXI2_net09_68 (c_144_p c_116_n) resistor r=89.3538
    rXI2_net09_67 (I2_MM4_d I2_net09_27) resistor r=0.217143
    rXI2_net09_66 (I2_MM6_d c_119_n) resistor r=0.170787
    rXI2_net09_65 (I2_net09 c_144_p) resistor r=4.7687
    rXI3_net13_86 (I3_MM4_g I3_net13_4) resistor r=45.24
    rXI3_net13_85 (I3_net13 I3_net13_4) resistor r=1.98872
    rXI3_net13_84 (I3_MM6_g I3_net13_8) resistor r=24.18
    rXI3_net13_83 (I3_net13 I3_net13_8) resistor r=1.98872
    rXI3_net13_82 (c_66_n I3_MM5_d) resistor r=0.244533
    rXI3_net13_81 (I3_net13_32 I3_MM5_d) resistor r=0.297556
    rXI3_net13_80 (I3_net13_15 c_61_n) resistor r=1.46154
    rXI3_net13_79 (c_68_n c_61_n) resistor r=0.0418175
    rXI3_net13_78 (I3_net13_26 I3_net13_15) resistor r=0.0223169
    rXI3_net13_77 (c_66_n I3_MM3_s) resistor r=0.584615
    rXI3_net13_76 (I3_net13_32 c_55_n) resistor r=1.92923
    rXI3_net13_75 (c_68_n c_55_n) resistor r=0.160909
    rXI3_net13_74 (c_56_n I3_net13_20) resistor r=0.38
    rXI3_net13_73 (c_68_n I3_net13_20) resistor r=0.160909
    rXI3_net13_72 (I3_net13_35 c_56_n) resistor r=0.137809
    rXI3_net13_71 (I3_net13_26 c_57_n) resistor r=0.204615
    rXI3_net13_70 (I3_net13_24 c_57_n) resistor r=89.3538
    rXI3_net13_69 (I3_net13 I3_net13_24) resistor r=2.34
    rXI3_net13_68 (I3_net13_35 I3_MM7_d) resistor r=0.132377
    rXI3_net09_82 (I3_MM5_g I3_net09_4) resistor r=24.96
    rXI3_net09_81 (c_36_p I3_net09_4) resistor r=4.7687
    rXI3_net09_80 (I3_net09 I3_MM7_g) resistor r=44.46
    rXI3_net09_79 (c_4_n I3_net09_14) resistor r=0.38
    rXI3_net09_78 (I3_net09_27 I3_net09_14) resistor r=0.110354
    rXI3_net09_77 (c_11_n c_4_n) resistor r=0.160909
    rXI3_net09_76 (c_5_n I3_net09_16) resistor r=1.92923
    rXI3_net09_75 (c_11_n I3_net09_16) resistor r=0.160909
    rXI3_net09_74 (c_2_n c_5_n) resistor r=0.154478
    rXI3_net09_73 (c_7_n I3_MM2_s) resistor r=0.672308
    rXI3_net09_72 (I3_MM4_d c_7_n) resistor r=0.110354
    rXI3_net09_71 (I3_net09_21 c_8_n) resistor r=1.54923
    rXI3_net09_70 (I3_net09_22 c_8_n) resistor r=0.212317
    rXI3_net09_69 (c_11_n I3_net09_21) resistor r=0.0418175
    rXI3_net09_68 (c_9_n I3_net09_22) resistor r=0.394615
    rXI3_net09_67 (c_36_p c_9_n) resistor r=89.3538
    rXI3_net09_66 (I3_MM4_d I3_net09_27) resistor r=0.217143
    rXI3_net09_65 (I3_MM6_d c_2_n) resistor r=0.170787
    rXI3_net09_64 (I3_net09 c_36_p) resistor r=4.7687
ends sram_col_1b
// End of subcircuit definition.

// Library name: my_sram
// Cell name: Sim_whole_col
// View name: schematic
// Inherited view list: spectre cmos_sch cmos.sch schematic veriloga ahdl
// pspice dspf
I49 (gnd net024 in_WL3 vdd) inverter
I48 (gnd net022 in_WL2 vdd) inverter
I47 (gnd net023 in_WL1 vdd) inverter
I38 (gnd net08 SE vdd) inverter
I36 (gnd net07 in_WL0 vdd) inverter
I34 (gnd net06 in_Pre vdd) inverter
I24 (gnd net05 in_WEN vdd) inverter
I7 (gnd net2 in_D vdd) inverter
V2 (gnd 0) vsource dc=0 type=dc
V1 (vdd 0) vsource dc=vdd type=dc
I40 (gnd BL net027 vdd) my4InvLoad
I39 (gnd BLB net026 vdd) my4InvLoad
I46 (BL BLB in_D in_Pre SE in_WL0 in_WL1 in_WL2 in_WL3 in_WEN gnd vdd) \
        sram_col_1b
V11 (net024 gnd) vsource val1=1.1 val0=0 delay=0n  rise=50p fall=50p \
        period=1n type=bit \
        data="11111111111111111111111111111111111111111111111111100011111111111111111111100001" \
        rptstart=1 rpttimes=0
V10 (net022 gnd) vsource val1=1.1 val0=0 delay=0n  rise=50p fall=50p \
        period=1n type=bit \
        data="11111111111111111111111111111111111000111111111111111111111000011111111111111111" \
        rptstart=1 rpttimes=0
V8 (net023 gnd) vsource val1=1.1 val0=0 delay=0n  rise=50p fall=50p \
        period=1n type=bit \
        data="11111111111111111110001111111111111111111110000111111111111111111111111111111111" \
        rptstart=1 rpttimes=0
V6 (net08 gnd) vsource val1=1.1 val0=0 delay=0n  rise=50p fall=50p \
        period=1n type=bit \
        data="11111111111110011111111111111001111111111111100111111111111110011111111111111001" \
        rptstart=1 rpttimes=0
V5 (net07 gnd) vsource val1=1.1 val0=0 delay=0n  rise=50p fall=50p \
        period=1n type=bit \
        data="11100011111000011111111111100001111111111111111111111111111111111110001111111111" \
        rptstart=1 rpttimes=0
V3 (net06 gnd) vsource val1=1.1 val0=0 delay=0n  rise=50p fall=50p \
        period=1n type=bit \
        data="11000000110000001100000011000000110000001100000011000000110000001100000011000000" \
        rptstart=1 rpttimes=0
V7 (net05 gnd) vsource val1=1.1 val0=0 delay=0n  rise=50p fall=50p \
        period=1n type=bit \
        data="11100011111111111110001111111111111000111111111111100011111111111110001111111111" \
        rptstart=1 rpttimes=0
V9 (net2 gnd) vsource val1=1.1 val0=0 delay=0n  rise=50p fall=50p \
        period=1n type=bit \
        data="11111111111111110000000000000000111111111111111100000000000000001111111111111111" \
        rptstart=1 rpttimes=0
simulatorOptions options psfversion="1.1.0" reltol=1e-3 vabstol=1e-6 \
    iabstol=1e-12 temp=27 tnom=27 scalem=1.0 scale=1.0 gmin=1e-12 rforce=1 \
    maxnotes=5 maxwarns=5 digits=5 cols=80 pivrel=1e-3 \
    sensfile="../psf/sens.output" checklimitdest=psf
tran tran stop=100n errpreset=moderate write="spectre.ic" \
    writefinal="spectre.fc" annotate=status maxiters=5
finalTimeOP info what=oppoint where=rawfile
modelParameter info what=models where=rawfile
element info what=inst where=rawfile
outputParameter info what=output where=rawfile
designParamVals info what=parameters where=rawfile
primitives info what=primitives where=rawfile
subckts info what=subckts where=rawfile
save in_Pre in_D in_WEN BL BLB SE in_WL3 in_WL2 in_WL1 in_WL0
saveOptions options save=allpub

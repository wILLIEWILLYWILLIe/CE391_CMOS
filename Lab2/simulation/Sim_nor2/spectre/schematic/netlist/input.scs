// Design: EECS391/Sim_nor2
simulator lang=spectre
global 0
parameters vdd=1.1
include "/vol/eecs391/FreePDK45/ncsu_basekit/models/hspice/hspice_nom.include"

// EECS391/inverter/schematic
subckt inverter gnd in out vdd
    M0 (out in gnd gnd) NMOS_VTG w=400n l=50n ld=105n ls=105n m=1
    M1 (out in vdd vdd) PMOS_VTG w=600n l=50n ld=105n ls=105n m=1
ends inverter

// EECS391/NOR2/schematic
subckt NOR2 A B gnd out vdd
    M1 (out B net16 vdd) PMOS_VTG w=1.2u l=50n ld=105n ls=105n m=1
    M0 (net16 A vdd vdd) PMOS_VTG w=1.2u l=50n ld=105n ls=105n m=1
    M3 (out A gnd gnd) NMOS_VTG w=400n l=50n ld=105n ls=105n m=1
    M2 (out B gnd gnd) NMOS_VTG w=400n l=50n ld=105n ls=105n m=1
ends NOR2

// EECS391/Sim_nor2/schematic
I15 (gnd net04 in_B vdd) inverter
I13 (gnd out net09 vdd) inverter
I7 (gnd net2 in_A vdd) inverter
I9 (gnd out net08 vdd) inverter
I10 (gnd out net07 vdd) inverter
I11 (gnd out net06 vdd) inverter
V_A (net2 gnd) vsource dc=0 type=pulse val0=0 val1=1.1V period=10n delay=1n rise=20p fall=20p width=5n
V_B (net04 gnd) vsource dc=0 type=pulse val0=0 val1=1.1V period=20n delay=1n rise=20p fall=20p width=10n
V2 (gnd 0) vsource dc=0 type=dc
V1 (vdd 0) vsource dc=vdd type=dc
I16 (in_A in_B gnd out vdd) NOR2
simulatorOptions options temp=27
tran tran stop=50n errpreset=moderate
save I16:5 in_B in_A
